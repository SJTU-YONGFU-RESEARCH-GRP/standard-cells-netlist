.subckt tielo_x1 X VDD VSS
* Physical cell: abstract subckt (rails per PDK CDL; add PDK devices if needed).
XTIE0N X VDD VSS VSS nmos w=1u l=100n
.ends tielo_x1
