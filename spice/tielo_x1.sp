.subckt tielo_x1 L_LO VDD VSS
* Physical cell: abstract subckt (rails per PDK CDL; add PDK devices if needed).
.ends tielo_x1
