.subckt decap_x1 VDD VSS
* Physical cell: abstract subckt (rails per PDK CDL; add PDK devices if needed).
.ends decap_x1
