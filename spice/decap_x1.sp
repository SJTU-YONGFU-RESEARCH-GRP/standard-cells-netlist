.subckt decap_x1 VDD VSS
* Physical cell: abstract subckt (rails per PDK CDL; add PDK devices if needed).
CDECAP VDD VSS 1p
.ends decap_x1
