.subckt tiedin_x1 X VDD VSS
* Physical cell: abstract subckt (rails per PDK CDL; add PDK devices if needed).
.ends tiedin_x1
