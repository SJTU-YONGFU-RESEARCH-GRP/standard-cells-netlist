.subckt tappn_x1 VDD VSS VBP VBN
* Physical cell: abstract subckt (rails per PDK CDL; add PDK devices if needed).
.ends tappn_x1
