.subckt tapdn_x1 VDD VSS VBN
* Physical cell: abstract subckt (rails per PDK CDL; add PDK devices if needed).
.ends tapdn_x1
