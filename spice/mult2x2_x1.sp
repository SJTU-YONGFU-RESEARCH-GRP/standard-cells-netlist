.subckt mult2x2_x1 a0 a1 b0 b1 p0 p1 p2 p3 VDD VSS
* Abstract subckt: behavioral/LVS placeholder — no MOS instances in the template.
.ends mult2x2_x1
