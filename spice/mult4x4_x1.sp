.subckt mult4x4_x1 a0 a1 a2 a3 b0 b1 b2 b3 p0 p1 p2 p3 p4 p5 p6 p7 VDD VSS
* Abstract subckt: behavioral/LVS placeholder — no MOS instances in the template.
.ends mult4x4_x1
