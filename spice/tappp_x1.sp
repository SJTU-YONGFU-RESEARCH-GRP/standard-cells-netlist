.subckt tappp_x1 VDD VSS VDDR
* Physical cell: abstract subckt (rails per PDK CDL; add PDK devices if needed).
.ends tappp_x1
