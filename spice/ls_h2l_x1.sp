.subckt ls_h2l_x1 in0 out VDDL VDDH VSS
* Level shifter: in0, out, VDDL (low domain), VDDH (high domain), VSS.
.ends ls_h2l_x1
