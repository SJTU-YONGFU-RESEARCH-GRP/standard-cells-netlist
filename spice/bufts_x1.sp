.subckt bufts_x1 A EN X VDD VSS
.ends bufts_x1
