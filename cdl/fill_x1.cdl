* CDL/LVS-oriented netlist
.SUBCKT fill_x1 VDD VSS
* Physical cell: abstract subckt (rails per PDK CDL; add PDK devices if needed).
.ENDS fill_x1
