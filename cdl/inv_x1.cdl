* CDL/LVS-oriented netlist
.SUBCKT inv_x1 A X VDD VSS
XMP0 X A VDD VDD pmos w=2u l=100n
XMN0 X A VSS VSS nmos w=1u l=100n
.ENDS inv_x1
