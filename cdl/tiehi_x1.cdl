* CDL/LVS-oriented netlist
.SUBCKT tiehi_x1 X VDD VSS
* Physical cell: abstract subckt (rails per PDK CDL; add PDK devices if needed).
XTIE1P X VSS VDD VDD pmos w=2u l=100n
.ENDS tiehi_x1
