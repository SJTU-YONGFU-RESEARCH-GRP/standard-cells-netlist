* CDL/LVS-oriented netlist
.SUBCKT sighold_x1 SH VDD VSS
* Physical cell: abstract subckt (rails per PDK CDL; add PDK devices if needed).
.ENDS sighold_x1
