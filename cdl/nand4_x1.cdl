* CDL/LVS-oriented netlist
.SUBCKT nand4_x1 A1 A2 A3 A4 X VDD VSS
XMPA0 X A1 VDD VDD pmos w=2u l=100n
XMPB0 X A2 VDD VDD pmos w=2u l=100n
XMPC0 X A3 VDD VDD pmos w=2u l=100n
XMPD0 X A4 VDD VDD pmos w=2u l=100n
XMND0 X A4 na4_3 VSS nmos w=1u l=100n
XMNC0 na4_3 A3 na4_2 VSS nmos w=1u l=100n
XMNB0 na4_2 A2 na4_1 VSS nmos w=1u l=100n
XMNA0 na4_1 A1 VSS VSS nmos w=1u l=100n
.ENDS nand4_x1
