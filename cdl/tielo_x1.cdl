* CDL/LVS-oriented netlist
.SUBCKT tielo_x1 L_LO VDD VSS
* Physical cell: abstract subckt (rails per PDK CDL; add PDK devices if needed).
* Abstract subckt (no MOS instances).
* No transistor template was found for this kind/drive.
.ENDS tielo_x1
