* CDL/LVS-oriented netlist
.SUBCKT tielo_x1 L_LO VDD VSS
* Physical cell: abstract subckt (rails per PDK CDL; add PDK devices if needed).
.ENDS tielo_x1
