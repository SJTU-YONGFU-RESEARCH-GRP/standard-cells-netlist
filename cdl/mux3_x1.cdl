* CDL/LVS-oriented netlist
.SUBCKT mux3_x1 D0 D1 D2 S0 S1 X VDD VSS
* Abstract subckt: behavioral/LVS placeholder — no MOS instances in the template.
.ENDS mux3_x1
