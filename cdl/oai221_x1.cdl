* CDL/LVS-oriented netlist
.SUBCKT oai221_x1 A1 A2 B1 B2 X VDD VSS
* Abstract subckt: behavioral/LVS placeholder — no MOS instances in the template.
.ENDS oai221_x1
