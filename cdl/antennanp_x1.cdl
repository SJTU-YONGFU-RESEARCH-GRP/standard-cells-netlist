* CDL/LVS-oriented netlist
.SUBCKT antennanp_x1 A VDD VSS
* Physical cell: abstract subckt (rails per PDK CDL; add PDK devices if needed).
* Abstract subckt (no MOS instances).
* No transistor template was found for this kind/drive.
.ENDS antennanp_x1
