* CDL/LVS-oriented netlist
.SUBCKT fdpsbq_x1 Q CK D SD VDD VSS
XFDPSBQ_ck_P0 FDPSBQ_ck_b CK VDD VDD pmos w=2u l=100n
XFDPSBQ_ck_N0 FDPSBQ_ck_b CK VSS VSS nmos w=1u l=100n
XFDPSBQ_m_in_P FDPSBQ_m_n1 CK D VDD pmos w=2u l=100n
XFDPSBQ_m_in_N FDPSBQ_m_n1 FDPSBQ_ck_b D VSS nmos w=1u l=100n
XFDPSBQ_m_i1_P0 FDPSBQ_m_n2 FDPSBQ_m_n1 VDD VDD pmos w=2u l=100n
XFDPSBQ_m_i1_N0 FDPSBQ_m_n2 FDPSBQ_m_n1 VSS VSS nmos w=1u l=100n
XFDPSBQ_m_i2_P0 FDPSBQ_m_n1 FDPSBQ_m_n2 VDD VDD pmos w=2u l=100n
XFDPSBQ_m_i2_N0 FDPSBQ_m_n1 FDPSBQ_m_n2 VSS VSS nmos w=1u l=100n
XFDPSBQ_m_fb_P FDPSBQ_m_n1 FDPSBQ_ck_b FDPSBQ_m_n2 VDD pmos w=2u l=100n
XFDPSBQ_m_fb_N FDPSBQ_m_n1 CK FDPSBQ_m_n2 VSS nmos w=1u l=100n
XFDPSBQ_m_o_P0 FDPSBQ_qm FDPSBQ_m_n2 VDD VDD pmos w=2u l=100n
XFDPSBQ_m_o_N0 FDPSBQ_qm FDPSBQ_m_n2 VSS VSS nmos w=1u l=100n
XFDPSBQ_s_in_P FDPSBQ_s_n1 FDPSBQ_ck_b FDPSBQ_qm VDD pmos w=2u l=100n
XFDPSBQ_s_in_N FDPSBQ_s_n1 CK FDPSBQ_qm VSS nmos w=1u l=100n
XFDPSBQ_s_i1_P0 FDPSBQ_s_n2 FDPSBQ_s_n1 VDD VDD pmos w=2u l=100n
XFDPSBQ_s_i1_N0 FDPSBQ_s_n2 FDPSBQ_s_n1 VSS VSS nmos w=1u l=100n
XFDPSBQ_s_i2_P0 FDPSBQ_s_n1 FDPSBQ_s_n2 VDD VDD pmos w=2u l=100n
XFDPSBQ_s_i2_N0 FDPSBQ_s_n1 FDPSBQ_s_n2 VSS VSS nmos w=1u l=100n
XFDPSBQ_s_fb_P FDPSBQ_s_n1 CK FDPSBQ_s_n2 VDD pmos w=2u l=100n
XFDPSBQ_s_fb_N FDPSBQ_s_n1 FDPSBQ_ck_b FDPSBQ_s_n2 VSS nmos w=1u l=100n
XFDPSBQ_s_o_P0 Q FDPSBQ_s_n2 VDD VDD pmos w=2u l=100n
XFDPSBQ_s_o_N0 Q FDPSBQ_s_n2 VSS VSS nmos w=1u l=100n
XFDPSBQ_sdi_P0 FDPSBQ_sd_b SD VDD VDD pmos w=2u l=100n
XFDPSBQ_sdi_N0 FDPSBQ_sd_b SD VSS VSS nmos w=1u l=100n
XFDPSBQ_rst Q FDPSBQ_sd_b VDD VDD pmos w=2u l=100n
.ENDS fdpsbq_x1
