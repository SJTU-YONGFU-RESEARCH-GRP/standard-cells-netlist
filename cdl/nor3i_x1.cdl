* CDL/LVS-oriented netlist
.SUBCKT nor3i_x1 A1 A2 A3 X VDD VSS
* Abstract subckt: behavioral/LVS placeholder — no MOS instances in the template.
.ENDS nor3i_x1
