* CDL/LVS-oriented netlist
.SUBCKT mux4i_x1 D0 D1 D2 D3 S0 S1 X VDD VSS
* Abstract subckt: behavioral/LVS placeholder — no MOS instances in the template.
.ENDS mux4i_x1
