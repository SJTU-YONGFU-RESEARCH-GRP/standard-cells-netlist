* CDL/LVS-oriented netlist
.SUBCKT fdphq_x1 Q CK D EN VDD VSS
* Abstract subckt (no MOS instances).
* ref_lib analogue: provide a PDK-specific transistor netlist if needed.
* Use verilog/vhdl for functional simulation; provide a PDK-specific netlist for transistor-level.
.ENDS fdphq_x1
