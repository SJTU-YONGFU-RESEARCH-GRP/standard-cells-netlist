* CDL/LVS-oriented netlist
.SUBCKT nand3_x1 A1 A2 A3 X VDD VSS
XMPA0 X A1 VDD VDD pmos w=2u l=100n
XMPB0 X A2 VDD VDD pmos w=2u l=100n
XMPC0 X A3 VDD VDD pmos w=2u l=100n
XMNC0 X A3 nmid2 VSS nmos w=1u l=100n
XMNB0 nmid2 A2 nmid1 VSS nmos w=1u l=100n
XMNA0 nmid1 A1 VSS VSS nmos w=1u l=100n
.ENDS nand3_x1
