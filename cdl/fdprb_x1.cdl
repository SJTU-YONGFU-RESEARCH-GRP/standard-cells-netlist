* CDL/LVS-oriented netlist
.SUBCKT fdprb_x1 Q QN CK D RD VDD VSS
* Abstract subckt (no MOS instances).
* ref_lib analogue: provide a PDK-specific transistor netlist if needed.
* Use verilog/vhdl for functional simulation; provide a PDK-specific netlist for transistor-level.
.ENDS fdprb_x1
