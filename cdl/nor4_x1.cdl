* CDL/LVS-oriented netlist
.SUBCKT nor4_x1 A1 A2 A3 A4 X VDD VSS
XMPA0 no4_1 A1 VDD VDD pmos w=2u l=100n
XMPB0 no4_2 A2 no4_1 VDD pmos w=2u l=100n
XMPC0 no4_3 A3 no4_2 VDD pmos w=2u l=100n
XMPD0 X A4 no4_3 VDD pmos w=2u l=100n
XMNA0 X A1 VSS VSS nmos w=1u l=100n
XMNB0 X A2 VSS VSS nmos w=1u l=100n
XMNC0 X A3 VSS VSS nmos w=1u l=100n
XMND0 X A4 VSS VSS nmos w=1u l=100n
.ENDS nor4_x1
