* CDL/LVS-oriented netlist
.SUBCKT aoi222_x1 A1 A2 B1 B2 C1 C2 X VDD VSS
* Abstract subckt: behavioral/LVS placeholder — no MOS instances in the template.
.ENDS aoi222_x1
