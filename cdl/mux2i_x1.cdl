* CDL/LVS-oriented netlist
.SUBCKT mux2i_x1 D0 D1 S X VDD VSS
* Abstract subckt: behavioral/LVS placeholder — no MOS instances in the template.
.ENDS mux2i_x1
