* CDL/LVS-oriented netlist
.SUBCKT fdprbsbq_x1 Q CK D RD SD VDD VSS
* Abstract subckt (no MOS instances).
* ref_lib analogue: provide a PDK-specific transistor netlist if needed.
* Use verilog/vhdl for functional simulation; provide a PDK-specific netlist for transistor-level.
.ENDS fdprbsbq_x1
