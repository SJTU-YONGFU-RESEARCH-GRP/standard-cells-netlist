* CDL/LVS-oriented netlist
.SUBCKT ldprbq_x1 Q G D RD VDD VSS
* Abstract subckt: behavioral/LVS placeholder — no MOS instances in the template.
* ref_lib analogue: LIB_LDPRBQ_* in ref_lib/lib_hd_ref.v; LIBHD_* in ref_lib/lib_hd_ref.spx (rails often VDD VSS VBP VBN)
.ENDS ldprbq_x1
