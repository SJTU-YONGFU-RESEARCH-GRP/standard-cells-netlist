* CDL/LVS-oriented netlist
.SUBCKT ldnq_x1 Q G D VDD VSS
XLDN_g_P0 g_b G VDD VDD pmos w=2u l=100n
XLDN_g_N0 g_b G VSS VSS nmos w=1u l=100n
XLDN_in_P LDN_n1 G D VDD pmos w=2u l=100n
XLDN_in_N LDN_n1 g_b D VSS nmos w=1u l=100n
XLDN_i1_P0 LDN_n2 LDN_n1 VDD VDD pmos w=2u l=100n
XLDN_i1_N0 LDN_n2 LDN_n1 VSS VSS nmos w=1u l=100n
XLDN_i2_P0 LDN_n1 LDN_n2 VDD VDD pmos w=2u l=100n
XLDN_i2_N0 LDN_n1 LDN_n2 VSS VSS nmos w=1u l=100n
XLDN_fb_P LDN_n1 g_b LDN_n2 VDD pmos w=2u l=100n
XLDN_fb_N LDN_n1 G LDN_n2 VSS nmos w=1u l=100n
XLDN_o_P0 Q LDN_n2 VDD VDD pmos w=2u l=100n
XLDN_o_N0 Q LDN_n2 VSS VSS nmos w=1u l=100n
.ENDS ldnq_x1
