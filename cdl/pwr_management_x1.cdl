* CDL/LVS-oriented netlist
.SUBCKT pwr_management_x1 VDD VDDH VSS
* Power rail / header / footer / PM cell: VDD (core), VDDH (domain/I/O), VSS.
.ENDS pwr_management_x1
