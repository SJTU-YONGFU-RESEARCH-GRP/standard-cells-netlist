* CDL/LVS-oriented netlist
.SUBCKT fsdpmq_x1 Q CK D0 D1 S SI SE VDD VSS
* Abstract subckt: behavioral/LVS placeholder — no MOS instances in the template.
* ref_lib analogue: LIB_FSDPMQ_* in ref_lib/lib_hd_ref.v; LIBHD_* in ref_lib/lib_hd_ref.spx (rails often VDD VSS VBP VBN)
.ENDS fsdpmq_x1
