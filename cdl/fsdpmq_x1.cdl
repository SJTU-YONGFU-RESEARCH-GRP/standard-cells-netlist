* CDL/LVS-oriented netlist
.SUBCKT fsdpmq_x1 Q CK D0 D1 S SI SE VDD VSS
* Abstract subckt (no MOS instances).
* ref_lib analogue: provide a PDK-specific transistor netlist if needed.
* Use verilog/vhdl for functional simulation; provide a PDK-specific netlist for transistor-level.
.ENDS fsdpmq_x1
