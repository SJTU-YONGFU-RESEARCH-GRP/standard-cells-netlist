* CDL/LVS-oriented netlist
.SUBCKT or4i_x1 A1 A2 A3 A4 X VDD VSS
* Abstract subckt: behavioral/LVS placeholder — no MOS instances in the template.
.ENDS or4i_x1
