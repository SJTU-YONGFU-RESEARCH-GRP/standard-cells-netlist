* CDL/LVS-oriented netlist
.SUBCKT isos0cl1_x1 VDD VSS VDDR VBP VBN X A EN0
* Power-management helper: ref_lib-style rails listed first (VDD,VSS,VDDR,VBP,VBN).
* Abstract subckt (no MOS instances).
* No transistor template was found for this kind/drive.
.ENDS isos0cl1_x1
