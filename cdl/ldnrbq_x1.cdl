* CDL/LVS-oriented netlist
.SUBCKT ldnrbq_x1 Q G D RD VDD VSS
* Abstract subckt (no MOS instances).
* ref_lib analogue: provide a PDK-specific transistor netlist if needed.
* Use verilog/vhdl for functional simulation; provide a PDK-specific netlist for transistor-level.
.ENDS ldnrbq_x1
