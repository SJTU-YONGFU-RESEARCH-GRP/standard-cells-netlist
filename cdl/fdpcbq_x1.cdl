* CDL/LVS-oriented netlist
.SUBCKT fdpcbq_x1 Q CK D RS VDD VSS
* Abstract subckt: behavioral/LVS placeholder — no MOS instances in the template.
* ref_lib analogue: LIB_FDPCBQ_* in ref_lib/lib_hd_ref.v; LIBHD_* in ref_lib/lib_hd_ref.spx (rails often VDD VSS VBP VBN)
.ENDS fdpcbq_x1
