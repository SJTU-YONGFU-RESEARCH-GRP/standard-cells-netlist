* CDL/LVS-oriented netlist
.SUBCKT pgatbdrv_x1 VDDP VSS VBP VBN VDDC ENX EN
* Power-management helper: ref_lib-style rails listed first (VDD,VSS,VDDR,VBP,VBN).
* Abstract subckt (no MOS instances).
* No transistor template was found for this kind/drive.
.ENDS pgatbdrv_x1
