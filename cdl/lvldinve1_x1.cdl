* CDL/LVS-oriented netlist
.SUBCKT lvldinve1_x1 VDD VSS VDDR VBP VBN X A EN
* Power-management helper: ref_lib-style rails listed first.
XN2P1 X A VDDR VBP pmos w=2u l=100n
XN2P2 X EN VDDR VBP pmos w=2u l=100n
XN2N1 X A n_nand2_mid VBN nmos w=1u l=100n
XN2N2 n_nand2_mid EN VSS VBN nmos w=1u l=100n
.ENDS lvldinve1_x1
