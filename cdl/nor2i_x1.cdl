* CDL/LVS-oriented netlist
.SUBCKT nor2i_x1 A B X VDD VSS
XMPA0 pmid_M0 A VDD VDD pmos w=2u l=100n
XMPB0 X B pmid_M0 VDD pmos w=2u l=100n
XMNA0 X A VSS VSS nmos w=1u l=100n
XMNB0 X B VSS VSS nmos w=1u l=100n
.ENDS nor2i_x1
