* CDL/LVS-oriented netlist
.SUBCKT decap_x1 VDD VSS
* Physical cell: abstract subckt (rails per PDK CDL; add PDK devices if needed).
CDECAP VDD VSS 1p
.ENDS decap_x1
