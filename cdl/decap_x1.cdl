* CDL/LVS-oriented netlist
.SUBCKT decap_x1 VDD VSS
* Physical cell: abstract subckt (rails per PDK CDL; add PDK devices if needed).
.ENDS decap_x1
