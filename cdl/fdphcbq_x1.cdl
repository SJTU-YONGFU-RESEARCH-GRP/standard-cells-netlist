* CDL/LVS-oriented netlist
.SUBCKT fdphcbq_x1 Q CK D EN RS VDD VSS
* Abstract subckt: behavioral/LVS placeholder — no MOS instances in the template.
* ref_lib analogue: LIB_FDPHCBQ_* in ref_lib/lib_hd_ref.v; LIBHD_* in ref_lib/lib_hd_ref.spx (rails often VDD VSS VBP VBN)
.ENDS fdphcbq_x1
