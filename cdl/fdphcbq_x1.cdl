* CDL/LVS-oriented netlist
.SUBCKT fdphcbq_x1 Q CK D EN RS VDD VSS
* Abstract subckt (no MOS instances).
* ref_lib analogue: provide a PDK-specific transistor netlist if needed.
* Use verilog/vhdl for functional simulation; provide a PDK-specific netlist for transistor-level.
.ENDS fdphcbq_x1
