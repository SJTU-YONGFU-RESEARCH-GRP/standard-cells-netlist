* CDL/LVS-oriented netlist
.SUBCKT addf42_x1 S CO ICO A B C D CI VDD VSS
* Abstract subckt: behavioral/LVS placeholder — no MOS instances in the template.
.ENDS addf42_x1
