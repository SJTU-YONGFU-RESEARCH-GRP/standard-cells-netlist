* CDL/LVS-oriented netlist
.SUBCKT oaoi211_x1 A1 A2 B1 B2 X VDD VSS
* Abstract subckt: behavioral/LVS placeholder — no MOS instances in the template.
.ENDS oaoi211_x1
