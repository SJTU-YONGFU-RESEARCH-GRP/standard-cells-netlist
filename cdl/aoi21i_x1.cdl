* CDL/LVS-oriented netlist
.SUBCKT aoi21i_x1 A1 A2 B X VDD VSS
* Abstract subckt: behavioral/LVS placeholder — no MOS instances in the template.
.ENDS aoi21i_x1
