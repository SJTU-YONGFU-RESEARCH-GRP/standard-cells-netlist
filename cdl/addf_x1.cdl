* CDL/LVS-oriented netlist
.SUBCKT addf_x1 S CO A B CI VDD VSS
* Abstract subckt (no MOS instances).
* ref_lib analogue: provide a PDK-specific transistor netlist if needed.
* Use verilog/vhdl for functional simulation; provide a PDK-specific netlist for transistor-level.
.ENDS addf_x1
