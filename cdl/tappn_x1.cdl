* CDL/LVS-oriented netlist
.SUBCKT tappn_x1 VDD VSS VBP VBN
* Physical cell: abstract subckt (rails per PDK CDL; add PDK devices if needed).
* Abstract subckt (no MOS instances).
* No transistor template was found for this kind/drive.
.ENDS tappn_x1
