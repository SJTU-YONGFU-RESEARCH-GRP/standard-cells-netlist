* CDL/LVS-oriented netlist
.SUBCKT fsdprbsbq_x1 Q CK D SI SE RD SD VDD VSS
XFSDPRBSBQ_sei_P0 FSDPRBSBQ_se_b SE VDD VDD pmos w=2u l=100n
XFSDPRBSBQ_sei_N0 FSDPRBSBQ_se_b SE VSS VSS nmos w=1u l=100n
XFSDPRBSBQ_smx_MP0 FSDPRBSBQ_din SE D VDD pmos w=2u l=100n
XFSDPRBSBQ_smx_MN0 FSDPRBSBQ_din FSDPRBSBQ_se_b D VSS nmos w=1u l=100n
XFSDPRBSBQ_smx_MP1 FSDPRBSBQ_din FSDPRBSBQ_se_b SI VDD pmos w=2u l=100n
XFSDPRBSBQ_smx_MN1 FSDPRBSBQ_din SE SI VSS nmos w=1u l=100n
XFSDPRBSBQ_ck_P0 FSDPRBSBQ_ck_b CK VDD VDD pmos w=2u l=100n
XFSDPRBSBQ_ck_N0 FSDPRBSBQ_ck_b CK VSS VSS nmos w=1u l=100n
XFSDPRBSBQ_m_in_P FSDPRBSBQ_m_n1 CK FSDPRBSBQ_din VDD pmos w=2u l=100n
XFSDPRBSBQ_m_in_N FSDPRBSBQ_m_n1 FSDPRBSBQ_ck_b FSDPRBSBQ_din VSS nmos w=1u l=100n
XFSDPRBSBQ_m_i1_P0 FSDPRBSBQ_m_n2 FSDPRBSBQ_m_n1 VDD VDD pmos w=2u l=100n
XFSDPRBSBQ_m_i1_N0 FSDPRBSBQ_m_n2 FSDPRBSBQ_m_n1 VSS VSS nmos w=1u l=100n
XFSDPRBSBQ_m_i2_P0 FSDPRBSBQ_m_n1 FSDPRBSBQ_m_n2 VDD VDD pmos w=2u l=100n
XFSDPRBSBQ_m_i2_N0 FSDPRBSBQ_m_n1 FSDPRBSBQ_m_n2 VSS VSS nmos w=1u l=100n
XFSDPRBSBQ_m_fb_P FSDPRBSBQ_m_n1 FSDPRBSBQ_ck_b FSDPRBSBQ_m_n2 VDD pmos w=2u l=100n
XFSDPRBSBQ_m_fb_N FSDPRBSBQ_m_n1 CK FSDPRBSBQ_m_n2 VSS nmos w=1u l=100n
XFSDPRBSBQ_m_o_P0 FSDPRBSBQ_qm FSDPRBSBQ_m_n2 VDD VDD pmos w=2u l=100n
XFSDPRBSBQ_m_o_N0 FSDPRBSBQ_qm FSDPRBSBQ_m_n2 VSS VSS nmos w=1u l=100n
XFSDPRBSBQ_s_in_P FSDPRBSBQ_s_n1 FSDPRBSBQ_ck_b FSDPRBSBQ_qm VDD pmos w=2u l=100n
XFSDPRBSBQ_s_in_N FSDPRBSBQ_s_n1 CK FSDPRBSBQ_qm VSS nmos w=1u l=100n
XFSDPRBSBQ_s_i1_P0 FSDPRBSBQ_s_n2 FSDPRBSBQ_s_n1 VDD VDD pmos w=2u l=100n
XFSDPRBSBQ_s_i1_N0 FSDPRBSBQ_s_n2 FSDPRBSBQ_s_n1 VSS VSS nmos w=1u l=100n
XFSDPRBSBQ_s_i2_P0 FSDPRBSBQ_s_n1 FSDPRBSBQ_s_n2 VDD VDD pmos w=2u l=100n
XFSDPRBSBQ_s_i2_N0 FSDPRBSBQ_s_n1 FSDPRBSBQ_s_n2 VSS VSS nmos w=1u l=100n
XFSDPRBSBQ_s_fb_P FSDPRBSBQ_s_n1 CK FSDPRBSBQ_s_n2 VDD pmos w=2u l=100n
XFSDPRBSBQ_s_fb_N FSDPRBSBQ_s_n1 FSDPRBSBQ_ck_b FSDPRBSBQ_s_n2 VSS nmos w=1u l=100n
XFSDPRBSBQ_s_o_P0 Q FSDPRBSBQ_s_n2 VDD VDD pmos w=2u l=100n
XFSDPRBSBQ_s_o_N0 Q FSDPRBSBQ_s_n2 VSS VSS nmos w=1u l=100n
XFSDPRBSBQ_rdi_P0 FSDPRBSBQ_rd_b RD VDD VDD pmos w=2u l=100n
XFSDPRBSBQ_rdi_N0 FSDPRBSBQ_rd_b RD VSS VSS nmos w=1u l=100n
XFSDPRBSBQ_rcl Q FSDPRBSBQ_rd_b VSS VSS nmos w=1u l=100n
XFSDPRBSBQ_sdi_P0 FSDPRBSBQ_sd_b SD VDD VDD pmos w=2u l=100n
XFSDPRBSBQ_sdi_N0 FSDPRBSBQ_sd_b SD VSS VSS nmos w=1u l=100n
XFSDPRBSBQ_rst Q FSDPRBSBQ_sd_b VDD VDD pmos w=2u l=100n
.ENDS fsdprbsbq_x1
