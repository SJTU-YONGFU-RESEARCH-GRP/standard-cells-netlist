* CDL/LVS-oriented netlist
.SUBCKT tiesub_x1 VDD VSS
* Physical cell: abstract subckt (rails per PDK CDL; add PDK devices if needed).
* Abstract subckt (no MOS instances).
* No transistor template was found for this kind/drive.
.ENDS tiesub_x1
