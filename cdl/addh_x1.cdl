* CDL/LVS-oriented netlist
.SUBCKT addh_x1 S CO A B VDD VSS
* Abstract subckt: behavioral/LVS placeholder — no MOS instances in the template.
.ENDS addh_x1
