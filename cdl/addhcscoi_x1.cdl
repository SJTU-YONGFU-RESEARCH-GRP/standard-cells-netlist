* CDL/LVS-oriented netlist
.SUBCKT addhcscoi_x1 S CO0 CO1 A B CI VDD VSS
* Abstract subckt (no MOS instances).
* ref_lib analogue: provide a PDK-specific transistor netlist if needed.
* Use verilog/vhdl for functional simulation; provide a PDK-specific netlist for transistor-level.
.ENDS addhcscoi_x1
