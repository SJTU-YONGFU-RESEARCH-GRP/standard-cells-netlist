* CDL/LVS-oriented netlist
.SUBCKT addhcscoi_x1 S CO0 CO1 A B CI VDD VSS
* Abstract subckt: behavioral/LVS placeholder — no MOS instances in the template.
.ENDS addhcscoi_x1
