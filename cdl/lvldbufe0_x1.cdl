* CDL/LVS-oriented netlist
.SUBCKT lvldbufe0_x1 VDD VSS VDDR VBP VBN X A EN
* Power-management helper: ref_lib-style rails listed first (VDD,VSS,VDDR,VBP,VBN).
* Abstract subckt (no MOS instances).
* No transistor template was found for this kind/drive.
.ENDS lvldbufe0_x1
