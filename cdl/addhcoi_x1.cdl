* CDL/LVS-oriented netlist
.SUBCKT addhcoi_x1 S CO A B VDD VSS
* Abstract subckt: behavioral/LVS placeholder — no MOS instances in the template.
.ENDS addhcoi_x1
