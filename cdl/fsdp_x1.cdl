* CDL/LVS-oriented netlist
.SUBCKT fsdp_x1 Q QN CK D SI SE VDD VSS
* Abstract subckt (no MOS instances).
* ref_lib analogue: provide a PDK-specific transistor netlist if needed.
* Use verilog/vhdl for functional simulation; provide a PDK-specific netlist for transistor-level.
.ENDS fsdp_x1
