* CDL/LVS-oriented netlist
.SUBCKT ao2ii2_x1 A1 A2 B1 B2 X VDD VSS
* Abstract subckt: behavioral/LVS placeholder — no MOS instances in the template.
.ENDS ao2ii2_x1
