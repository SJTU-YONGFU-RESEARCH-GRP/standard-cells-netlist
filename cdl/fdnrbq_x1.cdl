* CDL/LVS-oriented netlist
.SUBCKT fdnrbq_x1 Q CK D RD VDD VSS
* Abstract subckt (no MOS instances).
* ref_lib analogue: provide a PDK-specific transistor netlist if needed.
* Use verilog/vhdl for functional simulation; provide a PDK-specific netlist for transistor-level.
.ENDS fdnrbq_x1
