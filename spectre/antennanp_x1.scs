subckt antennanp_x1 A VDD VSS
* Physical cell: abstract subckt (rails per PDK CDL; add PDK devices if needed).
ends antennanp_x1
