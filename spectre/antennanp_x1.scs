subckt antennanp_x1 A VDD VSS
* Physical cell: abstract subckt (rails per PDK CDL; add PDK devices if needed).
ANTN (A A VSS VSS) nmos w=1u l=100n
ends antennanp_x1
