subckt fsdprbsbq_x1 Q CK D SI SE RD SD VDD VSS
FSDPRBSBQ_sei_P0 (FSDPRBSBQ_se_b SE VDD VDD) pmos w=2u l=100n
FSDPRBSBQ_sei_N0 (FSDPRBSBQ_se_b SE VSS VSS) nmos w=1u l=100n
FSDPRBSBQ_smx_MP0 (FSDPRBSBQ_din SE D VDD) pmos w=2u l=100n
FSDPRBSBQ_smx_MN0 (FSDPRBSBQ_din FSDPRBSBQ_se_b D VSS) nmos w=1u l=100n
FSDPRBSBQ_smx_MP1 (FSDPRBSBQ_din FSDPRBSBQ_se_b SI VDD) pmos w=2u l=100n
FSDPRBSBQ_smx_MN1 (FSDPRBSBQ_din SE SI VSS) nmos w=1u l=100n
FSDPRBSBQ_ck_P0 (FSDPRBSBQ_ck_b CK VDD VDD) pmos w=2u l=100n
FSDPRBSBQ_ck_N0 (FSDPRBSBQ_ck_b CK VSS VSS) nmos w=1u l=100n
FSDPRBSBQ_m_in_P (FSDPRBSBQ_m_n1 CK FSDPRBSBQ_din VDD) pmos w=2u l=100n
FSDPRBSBQ_m_in_N (FSDPRBSBQ_m_n1 FSDPRBSBQ_ck_b FSDPRBSBQ_din VSS) nmos w=1u l=100n
FSDPRBSBQ_m_i1_P0 (FSDPRBSBQ_m_n2 FSDPRBSBQ_m_n1 VDD VDD) pmos w=2u l=100n
FSDPRBSBQ_m_i1_N0 (FSDPRBSBQ_m_n2 FSDPRBSBQ_m_n1 VSS VSS) nmos w=1u l=100n
FSDPRBSBQ_m_i2_P0 (FSDPRBSBQ_m_n1 FSDPRBSBQ_m_n2 VDD VDD) pmos w=2u l=100n
FSDPRBSBQ_m_i2_N0 (FSDPRBSBQ_m_n1 FSDPRBSBQ_m_n2 VSS VSS) nmos w=1u l=100n
FSDPRBSBQ_m_fb_P (FSDPRBSBQ_m_n1 FSDPRBSBQ_ck_b FSDPRBSBQ_m_n2 VDD) pmos w=2u l=100n
FSDPRBSBQ_m_fb_N (FSDPRBSBQ_m_n1 CK FSDPRBSBQ_m_n2 VSS) nmos w=1u l=100n
FSDPRBSBQ_m_o_P0 (FSDPRBSBQ_qm FSDPRBSBQ_m_n2 VDD VDD) pmos w=2u l=100n
FSDPRBSBQ_m_o_N0 (FSDPRBSBQ_qm FSDPRBSBQ_m_n2 VSS VSS) nmos w=1u l=100n
FSDPRBSBQ_s_in_P (FSDPRBSBQ_s_n1 FSDPRBSBQ_ck_b FSDPRBSBQ_qm VDD) pmos w=2u l=100n
FSDPRBSBQ_s_in_N (FSDPRBSBQ_s_n1 CK FSDPRBSBQ_qm VSS) nmos w=1u l=100n
FSDPRBSBQ_s_i1_P0 (FSDPRBSBQ_s_n2 FSDPRBSBQ_s_n1 VDD VDD) pmos w=2u l=100n
FSDPRBSBQ_s_i1_N0 (FSDPRBSBQ_s_n2 FSDPRBSBQ_s_n1 VSS VSS) nmos w=1u l=100n
FSDPRBSBQ_s_i2_P0 (FSDPRBSBQ_s_n1 FSDPRBSBQ_s_n2 VDD VDD) pmos w=2u l=100n
FSDPRBSBQ_s_i2_N0 (FSDPRBSBQ_s_n1 FSDPRBSBQ_s_n2 VSS VSS) nmos w=1u l=100n
FSDPRBSBQ_s_fb_P (FSDPRBSBQ_s_n1 CK FSDPRBSBQ_s_n2 VDD) pmos w=2u l=100n
FSDPRBSBQ_s_fb_N (FSDPRBSBQ_s_n1 FSDPRBSBQ_ck_b FSDPRBSBQ_s_n2 VSS) nmos w=1u l=100n
FSDPRBSBQ_s_o_P0 (Q FSDPRBSBQ_s_n2 VDD VDD) pmos w=2u l=100n
FSDPRBSBQ_s_o_N0 (Q FSDPRBSBQ_s_n2 VSS VSS) nmos w=1u l=100n
FSDPRBSBQ_rdi_P0 (FSDPRBSBQ_rd_b RD VDD VDD) pmos w=2u l=100n
FSDPRBSBQ_rdi_N0 (FSDPRBSBQ_rd_b RD VSS VSS) nmos w=1u l=100n
FSDPRBSBQ_rcl (Q FSDPRBSBQ_rd_b VSS VSS) nmos w=1u l=100n
FSDPRBSBQ_sdi_P0 (FSDPRBSBQ_sd_b SD VDD VDD) pmos w=2u l=100n
FSDPRBSBQ_sdi_N0 (FSDPRBSBQ_sd_b SD VSS VSS) nmos w=1u l=100n
FSDPRBSBQ_rst (Q FSDPRBSBQ_sd_b VDD VDD) pmos w=2u l=100n
ends fsdprbsbq_x1
