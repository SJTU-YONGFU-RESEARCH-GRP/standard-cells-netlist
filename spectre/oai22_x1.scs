subckt oai22_x1 A1 A2 B1 B2 X VDD VSS
MNA10 (X A1 oai22_nmid VSS) nmos w=1u l=100n
MNA20 (X A2 oai22_nmid VSS) nmos w=1u l=100n
MNB10 (oai22_nmid B1 VSS VSS) nmos w=1u l=100n
MNB20 (oai22_nmid B2 VSS VSS) nmos w=1u l=100n
MPA10 (oai22_p_a A1 VDD VDD) pmos w=2u l=100n
MPA20 (X A2 oai22_p_a VDD) pmos w=2u l=100n
MPB10 (oai22_p_b B1 VDD VDD) pmos w=2u l=100n
MPB20 (X B2 oai22_p_b VDD) pmos w=2u l=100n
ends oai22_x1
