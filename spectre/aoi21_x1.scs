subckt aoi21_x1 A1 A2 B X VDD VSS
MNB0 (X B VSS VSS) nmos w=1u l=100n
MNA20 (aoi21_nsa A2 VSS VSS) nmos w=1u l=100n
MNA10 (X A1 aoi21_nsa VSS) nmos w=1u l=100n
MPB0 (aoi21_npb B VDD VDD) pmos w=2u l=100n
MPA10 (X A1 aoi21_npb VDD) pmos w=2u l=100n
MPA20 (X A2 aoi21_npb VDD) pmos w=2u l=100n
ends aoi21_x1
