subckt oai221_x1 A1 A2 B1 B2 C X VDD VSS
MNA10 (X A1 oai221_n1 VSS) nmos w=1u l=100n
MNA20 (X A2 oai221_n1 VSS) nmos w=1u l=100n
MNB10 (oai221_n1 B1 oai221_n2 VSS) nmos w=1u l=100n
MNB20 (oai221_n1 B2 oai221_n2 VSS) nmos w=1u l=100n
MNC0 (oai221_n2 C VSS VSS) nmos w=1u l=100n
MPA10 (oai221_p1a A1 VDD VDD) pmos w=2u l=100n
MPA20 (X A2 oai221_p1a VDD) pmos w=2u l=100n
MPB10 (oai221_p1b B1 VDD VDD) pmos w=2u l=100n
MPB20 (X B2 oai221_p1b VDD) pmos w=2u l=100n
MPC0 (X C VDD VDD) pmos w=2u l=100n
ends oai221_x1
