subckt oai21i_x1 A1 A2 B X VDD VSS
OAI21I_IN2_P0 (in2_b B VDD VDD) pmos w=2u l=100n
OAI21I_IN2_N0 (in2_b B VSS VSS) nmos w=1u l=100n
MNA10 (oai21_nor A1 VSS VSS) nmos w=1u l=100n
MNA20 (oai21_nor A2 VSS VSS) nmos w=1u l=100n
MNB0 (X in2_b oai21_nor VSS) nmos w=1u l=100n
MPA10 (oai21_pm A1 VDD VDD) pmos w=2u l=100n
MPA20 (X A2 oai21_pm VDD) pmos w=2u l=100n
MPB0 (X in2_b VDD VDD) pmos w=2u l=100n
ends oai21i_x1
