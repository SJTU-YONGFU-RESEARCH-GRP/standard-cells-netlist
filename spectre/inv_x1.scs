subckt inv_x1 A X VDD VSS
MP0 (X A VDD VDD) pmos w=2u l=100n
MN0 (X A VSS VSS) nmos w=1u l=100n
ends inv_x1
