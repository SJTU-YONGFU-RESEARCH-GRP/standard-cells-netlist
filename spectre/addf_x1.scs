subckt addf_x1 S CO A B CI VDD VSS
* Abstract subckt: behavioral/LVS placeholder — no MOS instances in the template.
ends addf_x1
