subckt fsdprbq_fv1_x1 Q CK D SI SE RD VDD VSS
FSDPRBQ_FV1_sei_P0 (FSDPRBQ_FV1_se_b SE VDD VDD) pmos w=2u l=100n
FSDPRBQ_FV1_sei_N0 (FSDPRBQ_FV1_se_b SE VSS VSS) nmos w=1u l=100n
FSDPRBQ_FV1_smx_MP0 (FSDPRBQ_FV1_din SE D VDD) pmos w=2u l=100n
FSDPRBQ_FV1_smx_MN0 (FSDPRBQ_FV1_din FSDPRBQ_FV1_se_b D VSS) nmos w=1u l=100n
FSDPRBQ_FV1_smx_MP1 (FSDPRBQ_FV1_din FSDPRBQ_FV1_se_b SI VDD) pmos w=2u l=100n
FSDPRBQ_FV1_smx_MN1 (FSDPRBQ_FV1_din SE SI VSS) nmos w=1u l=100n
FSDPRBQ_FV1_ck_P0 (FSDPRBQ_FV1_ck_b CK VDD VDD) pmos w=2u l=100n
FSDPRBQ_FV1_ck_N0 (FSDPRBQ_FV1_ck_b CK VSS VSS) nmos w=1u l=100n
FSDPRBQ_FV1_m_in_P (FSDPRBQ_FV1_m_n1 CK FSDPRBQ_FV1_din VDD) pmos w=2u l=100n
FSDPRBQ_FV1_m_in_N (FSDPRBQ_FV1_m_n1 FSDPRBQ_FV1_ck_b FSDPRBQ_FV1_din VSS) nmos w=1u l=100n
FSDPRBQ_FV1_m_i1_P0 (FSDPRBQ_FV1_m_n2 FSDPRBQ_FV1_m_n1 VDD VDD) pmos w=2u l=100n
FSDPRBQ_FV1_m_i1_N0 (FSDPRBQ_FV1_m_n2 FSDPRBQ_FV1_m_n1 VSS VSS) nmos w=1u l=100n
FSDPRBQ_FV1_m_i2_P0 (FSDPRBQ_FV1_m_n1 FSDPRBQ_FV1_m_n2 VDD VDD) pmos w=2u l=100n
FSDPRBQ_FV1_m_i2_N0 (FSDPRBQ_FV1_m_n1 FSDPRBQ_FV1_m_n2 VSS VSS) nmos w=1u l=100n
FSDPRBQ_FV1_m_fb_P (FSDPRBQ_FV1_m_n1 FSDPRBQ_FV1_ck_b FSDPRBQ_FV1_m_n2 VDD) pmos w=2u l=100n
FSDPRBQ_FV1_m_fb_N (FSDPRBQ_FV1_m_n1 CK FSDPRBQ_FV1_m_n2 VSS) nmos w=1u l=100n
FSDPRBQ_FV1_m_o_P0 (FSDPRBQ_FV1_qm FSDPRBQ_FV1_m_n2 VDD VDD) pmos w=2u l=100n
FSDPRBQ_FV1_m_o_N0 (FSDPRBQ_FV1_qm FSDPRBQ_FV1_m_n2 VSS VSS) nmos w=1u l=100n
FSDPRBQ_FV1_s_in_P (FSDPRBQ_FV1_s_n1 FSDPRBQ_FV1_ck_b FSDPRBQ_FV1_qm VDD) pmos w=2u l=100n
FSDPRBQ_FV1_s_in_N (FSDPRBQ_FV1_s_n1 CK FSDPRBQ_FV1_qm VSS) nmos w=1u l=100n
FSDPRBQ_FV1_s_i1_P0 (FSDPRBQ_FV1_s_n2 FSDPRBQ_FV1_s_n1 VDD VDD) pmos w=2u l=100n
FSDPRBQ_FV1_s_i1_N0 (FSDPRBQ_FV1_s_n2 FSDPRBQ_FV1_s_n1 VSS VSS) nmos w=1u l=100n
FSDPRBQ_FV1_s_i2_P0 (FSDPRBQ_FV1_s_n1 FSDPRBQ_FV1_s_n2 VDD VDD) pmos w=2u l=100n
FSDPRBQ_FV1_s_i2_N0 (FSDPRBQ_FV1_s_n1 FSDPRBQ_FV1_s_n2 VSS VSS) nmos w=1u l=100n
FSDPRBQ_FV1_s_fb_P (FSDPRBQ_FV1_s_n1 CK FSDPRBQ_FV1_s_n2 VDD) pmos w=2u l=100n
FSDPRBQ_FV1_s_fb_N (FSDPRBQ_FV1_s_n1 FSDPRBQ_FV1_ck_b FSDPRBQ_FV1_s_n2 VSS) nmos w=1u l=100n
FSDPRBQ_FV1_s_o_P0 (Q FSDPRBQ_FV1_s_n2 VDD VDD) pmos w=2u l=100n
FSDPRBQ_FV1_s_o_N0 (Q FSDPRBQ_FV1_s_n2 VSS VSS) nmos w=1u l=100n
FSDPRBQ_FV1_rdi_P0 (FSDPRBQ_FV1_rd_b RD VDD VDD) pmos w=2u l=100n
FSDPRBQ_FV1_rdi_N0 (FSDPRBQ_FV1_rd_b RD VSS VSS) nmos w=1u l=100n
FSDPRBQ_FV1_rcl (Q FSDPRBQ_FV1_rd_b VSS VSS) nmos w=1u l=100n
ends fsdprbq_fv1_x1
