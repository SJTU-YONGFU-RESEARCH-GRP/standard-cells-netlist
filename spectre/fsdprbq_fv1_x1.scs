subckt fsdprbq_fv1_x1 Q CK D SI SE RD VDD VSS
* Abstract subckt: behavioral/LVS placeholder — no MOS instances in the template.
* ref_lib analogue: LIB_FSDPRBQ_FV1_* in ref_lib/lib_hd_ref.v; LIBHD_* in ref_lib/lib_hd_ref.spx (rails often VDD VSS VBP VBN)
ends fsdprbq_fv1_x1
