subckt ebufn_x1 A TE_B X VDD VSS
TEI_P0 (te_n TE_B VDD VDD) pmos w=2u l=100n
TEI_N0 (te_n TE_B VSS VSS) nmos w=1u l=100n
EBP0 (X TE_B A VDD) pmos w=2u l=100n
EBN0 (X te_n A VSS) nmos w=1u l=100n
ends ebufn_x1
