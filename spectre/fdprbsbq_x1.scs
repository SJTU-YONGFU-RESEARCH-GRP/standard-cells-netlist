subckt fdprbsbq_x1 Q CK D RD SD VDD VSS
FDPRBS_ck_P0 (FDPRBS_ck_b CK VDD VDD) pmos w=2u l=100n
FDPRBS_ck_N0 (FDPRBS_ck_b CK VSS VSS) nmos w=1u l=100n
FDPRBS_m_in_P (FDPRBS_m_n1 CK D VDD) pmos w=2u l=100n
FDPRBS_m_in_N (FDPRBS_m_n1 FDPRBS_ck_b D VSS) nmos w=1u l=100n
FDPRBS_m_i1_P0 (FDPRBS_m_n2 FDPRBS_m_n1 VDD VDD) pmos w=2u l=100n
FDPRBS_m_i1_N0 (FDPRBS_m_n2 FDPRBS_m_n1 VSS VSS) nmos w=1u l=100n
FDPRBS_m_i2_P0 (FDPRBS_m_n1 FDPRBS_m_n2 VDD VDD) pmos w=2u l=100n
FDPRBS_m_i2_N0 (FDPRBS_m_n1 FDPRBS_m_n2 VSS VSS) nmos w=1u l=100n
FDPRBS_m_fb_P (FDPRBS_m_n1 FDPRBS_ck_b FDPRBS_m_n2 VDD) pmos w=2u l=100n
FDPRBS_m_fb_N (FDPRBS_m_n1 CK FDPRBS_m_n2 VSS) nmos w=1u l=100n
FDPRBS_m_o_P0 (FDPRBS_qm FDPRBS_m_n2 VDD VDD) pmos w=2u l=100n
FDPRBS_m_o_N0 (FDPRBS_qm FDPRBS_m_n2 VSS VSS) nmos w=1u l=100n
FDPRBS_s_in_P (FDPRBS_s_n1 FDPRBS_ck_b FDPRBS_qm VDD) pmos w=2u l=100n
FDPRBS_s_in_N (FDPRBS_s_n1 CK FDPRBS_qm VSS) nmos w=1u l=100n
FDPRBS_s_i1_P0 (FDPRBS_s_n2 FDPRBS_s_n1 VDD VDD) pmos w=2u l=100n
FDPRBS_s_i1_N0 (FDPRBS_s_n2 FDPRBS_s_n1 VSS VSS) nmos w=1u l=100n
FDPRBS_s_i2_P0 (FDPRBS_s_n1 FDPRBS_s_n2 VDD VDD) pmos w=2u l=100n
FDPRBS_s_i2_N0 (FDPRBS_s_n1 FDPRBS_s_n2 VSS VSS) nmos w=1u l=100n
FDPRBS_s_fb_P (FDPRBS_s_n1 CK FDPRBS_s_n2 VDD) pmos w=2u l=100n
FDPRBS_s_fb_N (FDPRBS_s_n1 FDPRBS_ck_b FDPRBS_s_n2 VSS) nmos w=1u l=100n
FDPRBS_s_o_P0 (Q FDPRBS_s_n2 VDD VDD) pmos w=2u l=100n
FDPRBS_s_o_N0 (Q FDPRBS_s_n2 VSS VSS) nmos w=1u l=100n
FDPRBS_rdi_P0 (FDPRBS_rd_b RD VDD VDD) pmos w=2u l=100n
FDPRBS_rdi_N0 (FDPRBS_rd_b RD VSS VSS) nmos w=1u l=100n
FDPRBS_rcl (Q FDPRBS_rd_b VSS VSS) nmos w=1u l=100n
FDPRBS_sdi_P0 (FDPRBS_sd_b SD VDD VDD) pmos w=2u l=100n
FDPRBS_sdi_N0 (FDPRBS_sd_b SD VSS VSS) nmos w=1u l=100n
FDPRBS_rst (Q FDPRBS_sd_b VDD VDD) pmos w=2u l=100n
ends fdprbsbq_x1
