subckt bmuxi_x1 S A X M0 M1 PP VDD VSS
* Abstract subckt: behavioral/LVS placeholder — no MOS instances in the template.
ends bmuxi_x1
