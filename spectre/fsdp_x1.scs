subckt fsdp_x1 Q QN CK D SI SE VDD VSS
* Abstract subckt: behavioral/LVS placeholder — no MOS instances in the template.
* ref_lib analogue: LIB_FSDP_* in ref_lib/lib_hd_ref.v; LIBHD_* in ref_lib/lib_hd_ref.spx (rails often VDD VSS VBP VBN)
ends fsdp_x1
