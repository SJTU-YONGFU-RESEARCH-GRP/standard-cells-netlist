subckt fsdp_x1 Q QN CK D SI SE VDD VSS
FSDP_sei_P0 (FSDP_se_b SE VDD VDD) pmos w=2u l=100n
FSDP_sei_N0 (FSDP_se_b SE VSS VSS) nmos w=1u l=100n
FSDP_smx_MP0 (FSDP_din SE D VDD) pmos w=2u l=100n
FSDP_smx_MN0 (FSDP_din FSDP_se_b D VSS) nmos w=1u l=100n
FSDP_smx_MP1 (FSDP_din FSDP_se_b SI VDD) pmos w=2u l=100n
FSDP_smx_MN1 (FSDP_din SE SI VSS) nmos w=1u l=100n
FSDP_ck_P0 (FSDP_ck_b CK VDD VDD) pmos w=2u l=100n
FSDP_ck_N0 (FSDP_ck_b CK VSS VSS) nmos w=1u l=100n
FSDP_m_in_P (FSDP_m_n1 CK FSDP_din VDD) pmos w=2u l=100n
FSDP_m_in_N (FSDP_m_n1 FSDP_ck_b FSDP_din VSS) nmos w=1u l=100n
FSDP_m_i1_P0 (FSDP_m_n2 FSDP_m_n1 VDD VDD) pmos w=2u l=100n
FSDP_m_i1_N0 (FSDP_m_n2 FSDP_m_n1 VSS VSS) nmos w=1u l=100n
FSDP_m_i2_P0 (FSDP_m_n1 FSDP_m_n2 VDD VDD) pmos w=2u l=100n
FSDP_m_i2_N0 (FSDP_m_n1 FSDP_m_n2 VSS VSS) nmos w=1u l=100n
FSDP_m_fb_P (FSDP_m_n1 FSDP_ck_b FSDP_m_n2 VDD) pmos w=2u l=100n
FSDP_m_fb_N (FSDP_m_n1 CK FSDP_m_n2 VSS) nmos w=1u l=100n
FSDP_m_o_P0 (FSDP_qm FSDP_m_n2 VDD VDD) pmos w=2u l=100n
FSDP_m_o_N0 (FSDP_qm FSDP_m_n2 VSS VSS) nmos w=1u l=100n
FSDP_s_in_P (FSDP_s_n1 FSDP_ck_b FSDP_qm VDD) pmos w=2u l=100n
FSDP_s_in_N (FSDP_s_n1 CK FSDP_qm VSS) nmos w=1u l=100n
FSDP_s_i1_P0 (FSDP_s_n2 FSDP_s_n1 VDD VDD) pmos w=2u l=100n
FSDP_s_i1_N0 (FSDP_s_n2 FSDP_s_n1 VSS VSS) nmos w=1u l=100n
FSDP_s_i2_P0 (FSDP_s_n1 FSDP_s_n2 VDD VDD) pmos w=2u l=100n
FSDP_s_i2_N0 (FSDP_s_n1 FSDP_s_n2 VSS VSS) nmos w=1u l=100n
FSDP_s_fb_P (FSDP_s_n1 CK FSDP_s_n2 VDD) pmos w=2u l=100n
FSDP_s_fb_N (FSDP_s_n1 FSDP_ck_b FSDP_s_n2 VSS) nmos w=1u l=100n
FSDP_s_o_P0 (Q FSDP_s_n2 VDD VDD) pmos w=2u l=100n
FSDP_s_o_N0 (Q FSDP_s_n2 VSS VSS) nmos w=1u l=100n
FSDP_qn_P0 (QN Q VDD VDD) pmos w=2u l=100n
FSDP_qn_N0 (QN Q VSS VSS) nmos w=1u l=100n
ends fsdp_x1
