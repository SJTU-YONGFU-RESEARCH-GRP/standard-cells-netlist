subckt aoi21i_x1 A1 A2 B X VDD VSS
* Abstract subckt: behavioral/LVS placeholder — no MOS instances in the template.
ends aoi21i_x1
