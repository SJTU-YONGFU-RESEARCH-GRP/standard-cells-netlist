subckt fsdpq_x1 Q CK D SI SE VDD VSS
FSDPQ_sei_P0 (FSDPQ_se_b SE VDD VDD) pmos w=2u l=100n
FSDPQ_sei_N0 (FSDPQ_se_b SE VSS VSS) nmos w=1u l=100n
FSDPQ_smx_MP0 (FSDPQ_din SE D VDD) pmos w=2u l=100n
FSDPQ_smx_MN0 (FSDPQ_din FSDPQ_se_b D VSS) nmos w=1u l=100n
FSDPQ_smx_MP1 (FSDPQ_din FSDPQ_se_b SI VDD) pmos w=2u l=100n
FSDPQ_smx_MN1 (FSDPQ_din SE SI VSS) nmos w=1u l=100n
FSDPQ_ck_P0 (FSDPQ_ck_b CK VDD VDD) pmos w=2u l=100n
FSDPQ_ck_N0 (FSDPQ_ck_b CK VSS VSS) nmos w=1u l=100n
FSDPQ_m_in_P (FSDPQ_m_n1 CK FSDPQ_din VDD) pmos w=2u l=100n
FSDPQ_m_in_N (FSDPQ_m_n1 FSDPQ_ck_b FSDPQ_din VSS) nmos w=1u l=100n
FSDPQ_m_i1_P0 (FSDPQ_m_n2 FSDPQ_m_n1 VDD VDD) pmos w=2u l=100n
FSDPQ_m_i1_N0 (FSDPQ_m_n2 FSDPQ_m_n1 VSS VSS) nmos w=1u l=100n
FSDPQ_m_i2_P0 (FSDPQ_m_n1 FSDPQ_m_n2 VDD VDD) pmos w=2u l=100n
FSDPQ_m_i2_N0 (FSDPQ_m_n1 FSDPQ_m_n2 VSS VSS) nmos w=1u l=100n
FSDPQ_m_fb_P (FSDPQ_m_n1 FSDPQ_ck_b FSDPQ_m_n2 VDD) pmos w=2u l=100n
FSDPQ_m_fb_N (FSDPQ_m_n1 CK FSDPQ_m_n2 VSS) nmos w=1u l=100n
FSDPQ_m_o_P0 (FSDPQ_qm FSDPQ_m_n2 VDD VDD) pmos w=2u l=100n
FSDPQ_m_o_N0 (FSDPQ_qm FSDPQ_m_n2 VSS VSS) nmos w=1u l=100n
FSDPQ_s_in_P (FSDPQ_s_n1 FSDPQ_ck_b FSDPQ_qm VDD) pmos w=2u l=100n
FSDPQ_s_in_N (FSDPQ_s_n1 CK FSDPQ_qm VSS) nmos w=1u l=100n
FSDPQ_s_i1_P0 (FSDPQ_s_n2 FSDPQ_s_n1 VDD VDD) pmos w=2u l=100n
FSDPQ_s_i1_N0 (FSDPQ_s_n2 FSDPQ_s_n1 VSS VSS) nmos w=1u l=100n
FSDPQ_s_i2_P0 (FSDPQ_s_n1 FSDPQ_s_n2 VDD VDD) pmos w=2u l=100n
FSDPQ_s_i2_N0 (FSDPQ_s_n1 FSDPQ_s_n2 VSS VSS) nmos w=1u l=100n
FSDPQ_s_fb_P (FSDPQ_s_n1 CK FSDPQ_s_n2 VDD) pmos w=2u l=100n
FSDPQ_s_fb_N (FSDPQ_s_n1 FSDPQ_ck_b FSDPQ_s_n2 VSS) nmos w=1u l=100n
FSDPQ_s_o_P0 (Q FSDPQ_s_n2 VDD VDD) pmos w=2u l=100n
FSDPQ_s_o_N0 (Q FSDPQ_s_n2 VSS VSS) nmos w=1u l=100n
ends fsdpq_x1
