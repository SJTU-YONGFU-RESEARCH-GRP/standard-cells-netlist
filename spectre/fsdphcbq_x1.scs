subckt fsdphcbq_x1 Q CK D SI SE EN RS VDD VSS
FSDPHCBQ_sei_P0 (FSDPHCBQ_se_b SE VDD VDD) pmos w=2u l=100n
FSDPHCBQ_sei_N0 (FSDPHCBQ_se_b SE VSS VSS) nmos w=1u l=100n
FSDPHCBQ_smx_MP0 (FSDPHCBQ_din SE D VDD) pmos w=2u l=100n
FSDPHCBQ_smx_MN0 (FSDPHCBQ_din FSDPHCBQ_se_b D VSS) nmos w=1u l=100n
FSDPHCBQ_smx_MP1 (FSDPHCBQ_din FSDPHCBQ_se_b SI VDD) pmos w=2u l=100n
FSDPHCBQ_smx_MN1 (FSDPHCBQ_din SE SI VSS) nmos w=1u l=100n
FSDPHCBQ_PA0 (fsdphcbq_and_n FSDPHCBQ_din VDD VDD) pmos w=2u l=100n
FSDPHCBQ_PB0 (fsdphcbq_and_n RS VDD VDD) pmos w=2u l=100n
FSDPHCBQ_NB0 (fsdphcbq_and_n RS nmid_FSDPHCBQ_0 VSS) nmos w=1u l=100n
FSDPHCBQ_NA0 (nmid_FSDPHCBQ_0 FSDPHCBQ_din VSS VSS) nmos w=1u l=100n
FSDPHCBQ_I_P0 (fsdphcbq_and fsdphcbq_and_n VDD VDD) pmos w=2u l=100n
FSDPHCBQ_I_N0 (fsdphcbq_and fsdphcbq_and_n VSS VSS) nmos w=1u l=100n
FSDPHCBQ_eni_P0 (FSDPHCBQ_en_b EN VDD VDD) pmos w=2u l=100n
FSDPHCBQ_eni_N0 (FSDPHCBQ_en_b EN VSS VSS) nmos w=1u l=100n
FSDPHCBQ_emx_MP0 (FSDPHCBQ_ed EN Q VDD) pmos w=2u l=100n
FSDPHCBQ_emx_MN0 (FSDPHCBQ_ed FSDPHCBQ_en_b Q VSS) nmos w=1u l=100n
FSDPHCBQ_emx_MP1 (FSDPHCBQ_ed FSDPHCBQ_en_b fsdphcbq_and VDD) pmos w=2u l=100n
FSDPHCBQ_emx_MN1 (FSDPHCBQ_ed EN fsdphcbq_and VSS) nmos w=1u l=100n
FSDPHCBQ_ck_P0 (FSDPHCBQ_ck_b CK VDD VDD) pmos w=2u l=100n
FSDPHCBQ_ck_N0 (FSDPHCBQ_ck_b CK VSS VSS) nmos w=1u l=100n
FSDPHCBQ_m_in_P (FSDPHCBQ_m_n1 CK FSDPHCBQ_ed VDD) pmos w=2u l=100n
FSDPHCBQ_m_in_N (FSDPHCBQ_m_n1 FSDPHCBQ_ck_b FSDPHCBQ_ed VSS) nmos w=1u l=100n
FSDPHCBQ_m_i1_P0 (FSDPHCBQ_m_n2 FSDPHCBQ_m_n1 VDD VDD) pmos w=2u l=100n
FSDPHCBQ_m_i1_N0 (FSDPHCBQ_m_n2 FSDPHCBQ_m_n1 VSS VSS) nmos w=1u l=100n
FSDPHCBQ_m_i2_P0 (FSDPHCBQ_m_n1 FSDPHCBQ_m_n2 VDD VDD) pmos w=2u l=100n
FSDPHCBQ_m_i2_N0 (FSDPHCBQ_m_n1 FSDPHCBQ_m_n2 VSS VSS) nmos w=1u l=100n
FSDPHCBQ_m_fb_P (FSDPHCBQ_m_n1 FSDPHCBQ_ck_b FSDPHCBQ_m_n2 VDD) pmos w=2u l=100n
FSDPHCBQ_m_fb_N (FSDPHCBQ_m_n1 CK FSDPHCBQ_m_n2 VSS) nmos w=1u l=100n
FSDPHCBQ_m_o_P0 (FSDPHCBQ_qm FSDPHCBQ_m_n2 VDD VDD) pmos w=2u l=100n
FSDPHCBQ_m_o_N0 (FSDPHCBQ_qm FSDPHCBQ_m_n2 VSS VSS) nmos w=1u l=100n
FSDPHCBQ_s_in_P (FSDPHCBQ_s_n1 FSDPHCBQ_ck_b FSDPHCBQ_qm VDD) pmos w=2u l=100n
FSDPHCBQ_s_in_N (FSDPHCBQ_s_n1 CK FSDPHCBQ_qm VSS) nmos w=1u l=100n
FSDPHCBQ_s_i1_P0 (FSDPHCBQ_s_n2 FSDPHCBQ_s_n1 VDD VDD) pmos w=2u l=100n
FSDPHCBQ_s_i1_N0 (FSDPHCBQ_s_n2 FSDPHCBQ_s_n1 VSS VSS) nmos w=1u l=100n
FSDPHCBQ_s_i2_P0 (FSDPHCBQ_s_n1 FSDPHCBQ_s_n2 VDD VDD) pmos w=2u l=100n
FSDPHCBQ_s_i2_N0 (FSDPHCBQ_s_n1 FSDPHCBQ_s_n2 VSS VSS) nmos w=1u l=100n
FSDPHCBQ_s_fb_P (FSDPHCBQ_s_n1 CK FSDPHCBQ_s_n2 VDD) pmos w=2u l=100n
FSDPHCBQ_s_fb_N (FSDPHCBQ_s_n1 FSDPHCBQ_ck_b FSDPHCBQ_s_n2 VSS) nmos w=1u l=100n
FSDPHCBQ_s_o_P0 (Q FSDPHCBQ_s_n2 VDD VDD) pmos w=2u l=100n
FSDPHCBQ_s_o_N0 (Q FSDPHCBQ_s_n2 VSS VSS) nmos w=1u l=100n
ends fsdphcbq_x1
