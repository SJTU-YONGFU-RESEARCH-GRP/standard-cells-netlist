subckt nand4i_x1 A1 A2 A3 A4 X VDD VSS
* Abstract subckt: behavioral/LVS placeholder — no MOS instances in the template.
ends nand4i_x1
