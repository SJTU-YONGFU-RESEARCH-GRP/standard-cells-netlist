subckt lvldbufe0_x1 VDD VSS VDDR VBP VBN X A EN
* Power-management helper: ref_lib-style rails listed first.
N2P1 (n_and A VDDR VBP) pmos w=2u l=100n
N2P2 (n_and EN VDDR VBP) pmos w=2u l=100n
N2N1 (n_and A n_nand2_mid VBN) nmos w=1u l=100n
N2N2 (n_nand2_mid EN VSS VBN) nmos w=1u l=100n
I3P (X n_and VDDR VBP) pmos w=2u l=100n
I3N (X n_and VSS VBN) nmos w=1u l=100n
ends lvldbufe0_x1
