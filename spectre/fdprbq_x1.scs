subckt fdprbq_x1 Q CK D RD VDD VSS
FDPRBQ_ck_P0 (FDPRBQ_ck_b CK VDD VDD) pmos w=2u l=100n
FDPRBQ_ck_N0 (FDPRBQ_ck_b CK VSS VSS) nmos w=1u l=100n
FDPRBQ_m_in_P (FDPRBQ_m_n1 CK D VDD) pmos w=2u l=100n
FDPRBQ_m_in_N (FDPRBQ_m_n1 FDPRBQ_ck_b D VSS) nmos w=1u l=100n
FDPRBQ_m_i1_P0 (FDPRBQ_m_n2 FDPRBQ_m_n1 VDD VDD) pmos w=2u l=100n
FDPRBQ_m_i1_N0 (FDPRBQ_m_n2 FDPRBQ_m_n1 VSS VSS) nmos w=1u l=100n
FDPRBQ_m_i2_P0 (FDPRBQ_m_n1 FDPRBQ_m_n2 VDD VDD) pmos w=2u l=100n
FDPRBQ_m_i2_N0 (FDPRBQ_m_n1 FDPRBQ_m_n2 VSS VSS) nmos w=1u l=100n
FDPRBQ_m_fb_P (FDPRBQ_m_n1 FDPRBQ_ck_b FDPRBQ_m_n2 VDD) pmos w=2u l=100n
FDPRBQ_m_fb_N (FDPRBQ_m_n1 CK FDPRBQ_m_n2 VSS) nmos w=1u l=100n
FDPRBQ_m_o_P0 (FDPRBQ_qm FDPRBQ_m_n2 VDD VDD) pmos w=2u l=100n
FDPRBQ_m_o_N0 (FDPRBQ_qm FDPRBQ_m_n2 VSS VSS) nmos w=1u l=100n
FDPRBQ_s_in_P (FDPRBQ_s_n1 FDPRBQ_ck_b FDPRBQ_qm VDD) pmos w=2u l=100n
FDPRBQ_s_in_N (FDPRBQ_s_n1 CK FDPRBQ_qm VSS) nmos w=1u l=100n
FDPRBQ_s_i1_P0 (FDPRBQ_s_n2 FDPRBQ_s_n1 VDD VDD) pmos w=2u l=100n
FDPRBQ_s_i1_N0 (FDPRBQ_s_n2 FDPRBQ_s_n1 VSS VSS) nmos w=1u l=100n
FDPRBQ_s_i2_P0 (FDPRBQ_s_n1 FDPRBQ_s_n2 VDD VDD) pmos w=2u l=100n
FDPRBQ_s_i2_N0 (FDPRBQ_s_n1 FDPRBQ_s_n2 VSS VSS) nmos w=1u l=100n
FDPRBQ_s_fb_P (FDPRBQ_s_n1 CK FDPRBQ_s_n2 VDD) pmos w=2u l=100n
FDPRBQ_s_fb_N (FDPRBQ_s_n1 FDPRBQ_ck_b FDPRBQ_s_n2 VSS) nmos w=1u l=100n
FDPRBQ_s_o_P0 (Q FDPRBQ_s_n2 VDD VDD) pmos w=2u l=100n
FDPRBQ_s_o_N0 (Q FDPRBQ_s_n2 VSS VSS) nmos w=1u l=100n
FDPRBQ_rdi_P0 (FDPRBQ_rd_b RD VDD VDD) pmos w=2u l=100n
FDPRBQ_rdi_N0 (FDPRBQ_rd_b RD VSS VSS) nmos w=1u l=100n
FDPRBQ_rcl (Q FDPRBQ_rd_b VSS VSS) nmos w=1u l=100n
ends fdprbq_x1
