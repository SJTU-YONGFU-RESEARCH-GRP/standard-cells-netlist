subckt mux16_x1 D0 D1 D2 D3 D4 D5 D6 D7 D8 D9 D10 D11 D12 D13 D14 D15 S0 S1 S2 S3 X VDD VSS
M16S0_P0 (s0_b S0 VDD VDD) pmos w=2u l=100n
M16S0_N0 (s0_b S0 VSS VSS) nmos w=1u l=100n
M16S1_P0 (s1_b S1 VDD VDD) pmos w=2u l=100n
M16S1_N0 (s1_b S1 VSS VSS) nmos w=1u l=100n
M16S2_P0 (s2_b S2 VDD VDD) pmos w=2u l=100n
M16S2_N0 (s2_b S2 VSS VSS) nmos w=1u l=100n
M16S3_P0 (s3_b S3 VDD VDD) pmos w=2u l=100n
M16S3_N0 (s3_b S3 VSS VSS) nmos w=1u l=100n
M16a0_0_MP0 (m16_l1_0_0 S0 D0 VDD) pmos w=2u l=100n
M16a0_0_MN0 (m16_l1_0_0 s0_b D0 VSS) nmos w=1u l=100n
M16a0_0_MP1 (m16_l1_0_0 s0_b D1 VDD) pmos w=2u l=100n
M16a0_0_MN1 (m16_l1_0_0 S0 D1 VSS) nmos w=1u l=100n
M16a0_1_MP0 (m16_l1_1_0 S0 D2 VDD) pmos w=2u l=100n
M16a0_1_MN0 (m16_l1_1_0 s0_b D2 VSS) nmos w=1u l=100n
M16a0_1_MP1 (m16_l1_1_0 s0_b D3 VDD) pmos w=2u l=100n
M16a0_1_MN1 (m16_l1_1_0 S0 D3 VSS) nmos w=1u l=100n
M16a0_2_MP0 (m16_l1_2_0 S0 D4 VDD) pmos w=2u l=100n
M16a0_2_MN0 (m16_l1_2_0 s0_b D4 VSS) nmos w=1u l=100n
M16a0_2_MP1 (m16_l1_2_0 s0_b D5 VDD) pmos w=2u l=100n
M16a0_2_MN1 (m16_l1_2_0 S0 D5 VSS) nmos w=1u l=100n
M16a0_3_MP0 (m16_l1_3_0 S0 D6 VDD) pmos w=2u l=100n
M16a0_3_MN0 (m16_l1_3_0 s0_b D6 VSS) nmos w=1u l=100n
M16a0_3_MP1 (m16_l1_3_0 s0_b D7 VDD) pmos w=2u l=100n
M16a0_3_MN1 (m16_l1_3_0 S0 D7 VSS) nmos w=1u l=100n
M16a0_4_MP0 (m16_l1_4_0 S0 D8 VDD) pmos w=2u l=100n
M16a0_4_MN0 (m16_l1_4_0 s0_b D8 VSS) nmos w=1u l=100n
M16a0_4_MP1 (m16_l1_4_0 s0_b D9 VDD) pmos w=2u l=100n
M16a0_4_MN1 (m16_l1_4_0 S0 D9 VSS) nmos w=1u l=100n
M16a0_5_MP0 (m16_l1_5_0 S0 D10 VDD) pmos w=2u l=100n
M16a0_5_MN0 (m16_l1_5_0 s0_b D10 VSS) nmos w=1u l=100n
M16a0_5_MP1 (m16_l1_5_0 s0_b D11 VDD) pmos w=2u l=100n
M16a0_5_MN1 (m16_l1_5_0 S0 D11 VSS) nmos w=1u l=100n
M16a0_6_MP0 (m16_l1_6_0 S0 D12 VDD) pmos w=2u l=100n
M16a0_6_MN0 (m16_l1_6_0 s0_b D12 VSS) nmos w=1u l=100n
M16a0_6_MP1 (m16_l1_6_0 s0_b D13 VDD) pmos w=2u l=100n
M16a0_6_MN1 (m16_l1_6_0 S0 D13 VSS) nmos w=1u l=100n
M16a0_7_MP0 (m16_l1_7_0 S0 D14 VDD) pmos w=2u l=100n
M16a0_7_MN0 (m16_l1_7_0 s0_b D14 VSS) nmos w=1u l=100n
M16a0_7_MP1 (m16_l1_7_0 s0_b D15 VDD) pmos w=2u l=100n
M16a0_7_MN1 (m16_l1_7_0 S0 D15 VSS) nmos w=1u l=100n
M16b0_0_MP0 (m16_l2_0_0 S1 m16_l1_0_0 VDD) pmos w=2u l=100n
M16b0_0_MN0 (m16_l2_0_0 s1_b m16_l1_0_0 VSS) nmos w=1u l=100n
M16b0_0_MP1 (m16_l2_0_0 s1_b m16_l1_1_0 VDD) pmos w=2u l=100n
M16b0_0_MN1 (m16_l2_0_0 S1 m16_l1_1_0 VSS) nmos w=1u l=100n
M16b0_1_MP0 (m16_l2_1_0 S1 m16_l1_2_0 VDD) pmos w=2u l=100n
M16b0_1_MN0 (m16_l2_1_0 s1_b m16_l1_2_0 VSS) nmos w=1u l=100n
M16b0_1_MP1 (m16_l2_1_0 s1_b m16_l1_3_0 VDD) pmos w=2u l=100n
M16b0_1_MN1 (m16_l2_1_0 S1 m16_l1_3_0 VSS) nmos w=1u l=100n
M16b0_2_MP0 (m16_l2_2_0 S1 m16_l1_4_0 VDD) pmos w=2u l=100n
M16b0_2_MN0 (m16_l2_2_0 s1_b m16_l1_4_0 VSS) nmos w=1u l=100n
M16b0_2_MP1 (m16_l2_2_0 s1_b m16_l1_5_0 VDD) pmos w=2u l=100n
M16b0_2_MN1 (m16_l2_2_0 S1 m16_l1_5_0 VSS) nmos w=1u l=100n
M16b0_3_MP0 (m16_l2_3_0 S1 m16_l1_6_0 VDD) pmos w=2u l=100n
M16b0_3_MN0 (m16_l2_3_0 s1_b m16_l1_6_0 VSS) nmos w=1u l=100n
M16b0_3_MP1 (m16_l2_3_0 s1_b m16_l1_7_0 VDD) pmos w=2u l=100n
M16b0_3_MN1 (m16_l2_3_0 S1 m16_l1_7_0 VSS) nmos w=1u l=100n
M16c0_0_MP0 (m16_l3_0_0 S2 m16_l2_0_0 VDD) pmos w=2u l=100n
M16c0_0_MN0 (m16_l3_0_0 s2_b m16_l2_0_0 VSS) nmos w=1u l=100n
M16c0_0_MP1 (m16_l3_0_0 s2_b m16_l2_1_0 VDD) pmos w=2u l=100n
M16c0_0_MN1 (m16_l3_0_0 S2 m16_l2_1_0 VSS) nmos w=1u l=100n
M16c0_1_MP0 (m16_l3_1_0 S2 m16_l2_2_0 VDD) pmos w=2u l=100n
M16c0_1_MN0 (m16_l3_1_0 s2_b m16_l2_2_0 VSS) nmos w=1u l=100n
M16c0_1_MP1 (m16_l3_1_0 s2_b m16_l2_3_0 VDD) pmos w=2u l=100n
M16c0_1_MN1 (m16_l3_1_0 S2 m16_l2_3_0 VSS) nmos w=1u l=100n
M16d0_MP0 (m16_y_0 S3 m16_l3_0_0 VDD) pmos w=2u l=100n
M16d0_MN0 (m16_y_0 s3_b m16_l3_0_0 VSS) nmos w=1u l=100n
M16d0_MP1 (m16_y_0 s3_b m16_l3_1_0 VDD) pmos w=2u l=100n
M16d0_MN1 (m16_y_0 S3 m16_l3_1_0 VSS) nmos w=1u l=100n
M16Oa0_P0 (m16_y_b_0 m16_y_0 VDD VDD) pmos w=2u l=100n
M16Oa0_N0 (m16_y_b_0 m16_y_0 VSS VSS) nmos w=1u l=100n
M16Ob0_P0 (X m16_y_b_0 VDD VDD) pmos w=2u l=100n
M16Ob0_N0 (X m16_y_b_0 VSS VSS) nmos w=1u l=100n
ends mux16_x1
