subckt pgatbfill_x1 VDDP VSS VBP VBN VDDCF ENX EN
* Power-management helper: ref_lib-style rails listed first (VDD,VSS,VDDR,VBP,VBN).
* Abstract subckt (no MOS instances).
* No transistor template was found for this kind/drive.
ends pgatbfill_x1
