subckt pgatbfill_x1 VDDP VSS VBP VBN VDDCF ENX EN
* Power-management helper: ref_lib-style rails listed first.
PG_ENX_POFF (ENX VDDP ENX VBP) pmos w=2u l=100n
PG_ENX_NOFF (ENX VSS ENX VBN) nmos w=1u l=100n
PG_EN_POFF (EN VDDP EN VBP) pmos w=2u l=100n
PG_EN_NOFF (EN VSS EN VBN) nmos w=1u l=100n
ends pgatbfill_x1
