subckt fsdphq_x1 Q CK D SI SE EN VDD VSS
FSDPHQ_sei_P0 (FSDPHQ_se_b SE VDD VDD) pmos w=2u l=100n
FSDPHQ_sei_N0 (FSDPHQ_se_b SE VSS VSS) nmos w=1u l=100n
FSDPHQ_smx_MP0 (FSDPHQ_din SE D VDD) pmos w=2u l=100n
FSDPHQ_smx_MN0 (FSDPHQ_din FSDPHQ_se_b D VSS) nmos w=1u l=100n
FSDPHQ_smx_MP1 (FSDPHQ_din FSDPHQ_se_b SI VDD) pmos w=2u l=100n
FSDPHQ_smx_MN1 (FSDPHQ_din SE SI VSS) nmos w=1u l=100n
FSDPHQ_eni_P0 (FSDPHQ_en_b EN VDD VDD) pmos w=2u l=100n
FSDPHQ_eni_N0 (FSDPHQ_en_b EN VSS VSS) nmos w=1u l=100n
FSDPHQ_emx_MP0 (FSDPHQ_ed EN Q VDD) pmos w=2u l=100n
FSDPHQ_emx_MN0 (FSDPHQ_ed FSDPHQ_en_b Q VSS) nmos w=1u l=100n
FSDPHQ_emx_MP1 (FSDPHQ_ed FSDPHQ_en_b FSDPHQ_din VDD) pmos w=2u l=100n
FSDPHQ_emx_MN1 (FSDPHQ_ed EN FSDPHQ_din VSS) nmos w=1u l=100n
FSDPHQ_ck_P0 (FSDPHQ_ck_b CK VDD VDD) pmos w=2u l=100n
FSDPHQ_ck_N0 (FSDPHQ_ck_b CK VSS VSS) nmos w=1u l=100n
FSDPHQ_m_in_P (FSDPHQ_m_n1 CK FSDPHQ_ed VDD) pmos w=2u l=100n
FSDPHQ_m_in_N (FSDPHQ_m_n1 FSDPHQ_ck_b FSDPHQ_ed VSS) nmos w=1u l=100n
FSDPHQ_m_i1_P0 (FSDPHQ_m_n2 FSDPHQ_m_n1 VDD VDD) pmos w=2u l=100n
FSDPHQ_m_i1_N0 (FSDPHQ_m_n2 FSDPHQ_m_n1 VSS VSS) nmos w=1u l=100n
FSDPHQ_m_i2_P0 (FSDPHQ_m_n1 FSDPHQ_m_n2 VDD VDD) pmos w=2u l=100n
FSDPHQ_m_i2_N0 (FSDPHQ_m_n1 FSDPHQ_m_n2 VSS VSS) nmos w=1u l=100n
FSDPHQ_m_fb_P (FSDPHQ_m_n1 FSDPHQ_ck_b FSDPHQ_m_n2 VDD) pmos w=2u l=100n
FSDPHQ_m_fb_N (FSDPHQ_m_n1 CK FSDPHQ_m_n2 VSS) nmos w=1u l=100n
FSDPHQ_m_o_P0 (FSDPHQ_qm FSDPHQ_m_n2 VDD VDD) pmos w=2u l=100n
FSDPHQ_m_o_N0 (FSDPHQ_qm FSDPHQ_m_n2 VSS VSS) nmos w=1u l=100n
FSDPHQ_s_in_P (FSDPHQ_s_n1 FSDPHQ_ck_b FSDPHQ_qm VDD) pmos w=2u l=100n
FSDPHQ_s_in_N (FSDPHQ_s_n1 CK FSDPHQ_qm VSS) nmos w=1u l=100n
FSDPHQ_s_i1_P0 (FSDPHQ_s_n2 FSDPHQ_s_n1 VDD VDD) pmos w=2u l=100n
FSDPHQ_s_i1_N0 (FSDPHQ_s_n2 FSDPHQ_s_n1 VSS VSS) nmos w=1u l=100n
FSDPHQ_s_i2_P0 (FSDPHQ_s_n1 FSDPHQ_s_n2 VDD VDD) pmos w=2u l=100n
FSDPHQ_s_i2_N0 (FSDPHQ_s_n1 FSDPHQ_s_n2 VSS VSS) nmos w=1u l=100n
FSDPHQ_s_fb_P (FSDPHQ_s_n1 CK FSDPHQ_s_n2 VDD) pmos w=2u l=100n
FSDPHQ_s_fb_N (FSDPHQ_s_n1 FSDPHQ_ck_b FSDPHQ_s_n2 VSS) nmos w=1u l=100n
FSDPHQ_s_o_P0 (Q FSDPHQ_s_n2 VDD VDD) pmos w=2u l=100n
FSDPHQ_s_o_N0 (Q FSDPHQ_s_n2 VSS VSS) nmos w=1u l=100n
ends fsdphq_x1
