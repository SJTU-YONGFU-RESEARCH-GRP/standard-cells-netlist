subckt nor4_x1 A1 A2 A3 A4 X VDD VSS
MPA0 (no4_1 A1 VDD VDD) pmos w=2u l=100n
MPB0 (no4_2 A2 no4_1 VDD) pmos w=2u l=100n
MPC0 (no4_3 A3 no4_2 VDD) pmos w=2u l=100n
MPD0 (X A4 no4_3 VDD) pmos w=2u l=100n
MNA0 (X A1 VSS VSS) nmos w=1u l=100n
MNB0 (X A2 VSS VSS) nmos w=1u l=100n
MNC0 (X A3 VSS VSS) nmos w=1u l=100n
MND0 (X A4 VSS VSS) nmos w=1u l=100n
ends nor4_x1
