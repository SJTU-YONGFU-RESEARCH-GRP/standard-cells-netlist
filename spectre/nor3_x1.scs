subckt nor3_x1 A1 A2 A3 X VDD VSS
MPA0 (pmid1 A1 VDD VDD) pmos w=2u l=100n
MPB0 (pmid2 A2 pmid1 VDD) pmos w=2u l=100n
MPC0 (X A3 pmid2 VDD) pmos w=2u l=100n
MNA0 (X A1 VSS VSS) nmos w=1u l=100n
MNB0 (X A2 VSS VSS) nmos w=1u l=100n
MNC0 (X A3 VSS VSS) nmos w=1u l=100n
ends nor3_x1
