subckt pwr_management_x1 VDD VDDH VSS
* Power rail / header / footer / PM cell: VDD (core), VDDH (domain/I/O), VSS.
* Abstract subckt (no MOS instances).
* No transistor template was found for this kind/drive.
ends pwr_management_x1
