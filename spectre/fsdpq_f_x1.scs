subckt fsdpq_f_x1 Q CK D SI SE VDD VSS
FSDPQ_F_sei_P0 (FSDPQ_F_se_b SE VDD VDD) pmos w=2u l=100n
FSDPQ_F_sei_N0 (FSDPQ_F_se_b SE VSS VSS) nmos w=1u l=100n
FSDPQ_F_smx_MP0 (FSDPQ_F_din SE D VDD) pmos w=2u l=100n
FSDPQ_F_smx_MN0 (FSDPQ_F_din FSDPQ_F_se_b D VSS) nmos w=1u l=100n
FSDPQ_F_smx_MP1 (FSDPQ_F_din FSDPQ_F_se_b SI VDD) pmos w=2u l=100n
FSDPQ_F_smx_MN1 (FSDPQ_F_din SE SI VSS) nmos w=1u l=100n
FSDPQ_F_ck_P0 (FSDPQ_F_ck_b CK VDD VDD) pmos w=2u l=100n
FSDPQ_F_ck_N0 (FSDPQ_F_ck_b CK VSS VSS) nmos w=1u l=100n
FSDPQ_F_m_in_P (FSDPQ_F_m_n1 CK FSDPQ_F_din VDD) pmos w=2u l=100n
FSDPQ_F_m_in_N (FSDPQ_F_m_n1 FSDPQ_F_ck_b FSDPQ_F_din VSS) nmos w=1u l=100n
FSDPQ_F_m_i1_P0 (FSDPQ_F_m_n2 FSDPQ_F_m_n1 VDD VDD) pmos w=2u l=100n
FSDPQ_F_m_i1_N0 (FSDPQ_F_m_n2 FSDPQ_F_m_n1 VSS VSS) nmos w=1u l=100n
FSDPQ_F_m_i2_P0 (FSDPQ_F_m_n1 FSDPQ_F_m_n2 VDD VDD) pmos w=2u l=100n
FSDPQ_F_m_i2_N0 (FSDPQ_F_m_n1 FSDPQ_F_m_n2 VSS VSS) nmos w=1u l=100n
FSDPQ_F_m_fb_P (FSDPQ_F_m_n1 FSDPQ_F_ck_b FSDPQ_F_m_n2 VDD) pmos w=2u l=100n
FSDPQ_F_m_fb_N (FSDPQ_F_m_n1 CK FSDPQ_F_m_n2 VSS) nmos w=1u l=100n
FSDPQ_F_m_o_P0 (FSDPQ_F_qm FSDPQ_F_m_n2 VDD VDD) pmos w=2u l=100n
FSDPQ_F_m_o_N0 (FSDPQ_F_qm FSDPQ_F_m_n2 VSS VSS) nmos w=1u l=100n
FSDPQ_F_s_in_P (FSDPQ_F_s_n1 FSDPQ_F_ck_b FSDPQ_F_qm VDD) pmos w=2u l=100n
FSDPQ_F_s_in_N (FSDPQ_F_s_n1 CK FSDPQ_F_qm VSS) nmos w=1u l=100n
FSDPQ_F_s_i1_P0 (FSDPQ_F_s_n2 FSDPQ_F_s_n1 VDD VDD) pmos w=2u l=100n
FSDPQ_F_s_i1_N0 (FSDPQ_F_s_n2 FSDPQ_F_s_n1 VSS VSS) nmos w=1u l=100n
FSDPQ_F_s_i2_P0 (FSDPQ_F_s_n1 FSDPQ_F_s_n2 VDD VDD) pmos w=2u l=100n
FSDPQ_F_s_i2_N0 (FSDPQ_F_s_n1 FSDPQ_F_s_n2 VSS VSS) nmos w=1u l=100n
FSDPQ_F_s_fb_P (FSDPQ_F_s_n1 CK FSDPQ_F_s_n2 VDD) pmos w=2u l=100n
FSDPQ_F_s_fb_N (FSDPQ_F_s_n1 FSDPQ_F_ck_b FSDPQ_F_s_n2 VSS) nmos w=1u l=100n
FSDPQ_F_s_o_P0 (Q FSDPQ_F_s_n2 VDD VDD) pmos w=2u l=100n
FSDPQ_F_s_o_N0 (Q FSDPQ_F_s_n2 VSS VSS) nmos w=1u l=100n
ends fsdpq_f_x1
