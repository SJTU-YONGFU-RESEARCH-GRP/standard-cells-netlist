subckt mux2i_x1 D0 D1 S X VDD VSS
* Abstract subckt: behavioral/LVS placeholder — no MOS instances in the template.
ends mux2i_x1
