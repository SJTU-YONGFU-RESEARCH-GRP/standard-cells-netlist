subckt tappp_x1 VDD VSS VDDR
* Physical cell: abstract subckt (rails per PDK CDL; add PDK devices if needed).
* Abstract subckt (no MOS instances).
* No transistor template was found for this kind/drive.
ends tappp_x1
