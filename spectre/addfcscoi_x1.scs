subckt addfcscoi_x1 S CO0 CO1 A B CI0 CI1 CS VDD VSS
ADFCS_X1_nr_PA0 (pmid_ADFCS_X1_nr_0 A VDD VDD) pmos w=2u l=100n
ADFCS_X1_nr_PB0 (x_nor_xab B pmid_ADFCS_X1_nr_0 VDD) pmos w=2u l=100n
ADFCS_X1_nr_NA0 (x_nor_xab A VSS VSS) nmos w=1u l=100n
ADFCS_X1_nr_NB0 (x_nor_xab B VSS VSS) nmos w=1u l=100n
ADFCS_X1_iv_P0 (x_or_xab x_nor_xab VDD VDD) pmos w=2u l=100n
ADFCS_X1_iv_N0 (x_or_xab x_nor_xab VSS VSS) nmos w=1u l=100n
ADFCS_X1_nd_PA0 (x_nand_xab A VDD VDD) pmos w=2u l=100n
ADFCS_X1_nd_PB0 (x_nand_xab B VDD VDD) pmos w=2u l=100n
ADFCS_X1_nd_NB0 (x_nand_xab B nmid_ADFCS_X1_nd_0 VSS) nmos w=1u l=100n
ADFCS_X1_nd_NA0 (nmid_ADFCS_X1_nd_0 A VSS VSS) nmos w=1u l=100n
ADFCS_X1_na_PA0 (x_pre_xab x_or_xab VDD VDD) pmos w=2u l=100n
ADFCS_X1_na_PB0 (x_pre_xab x_nand_xab VDD VDD) pmos w=2u l=100n
ADFCS_X1_na_NB0 (x_pre_xab x_nand_xab nmid_ADFCS_X1_na_0 VSS) nmos w=1u l=100n
ADFCS_X1_na_NA0 (nmid_ADFCS_X1_na_0 x_or_xab VSS VSS) nmos w=1u l=100n
ADFCS_X1_xo_P0 (adfcs_xab x_pre_xab VDD VDD) pmos w=2u l=100n
ADFCS_X1_xo_N0 (adfcs_xab x_pre_xab VSS VSS) nmos w=1u l=100n
ADFCS_X20_nr_PA0 (pmid_ADFCS_X20_nr_0 adfcs_xab VDD VDD) pmos w=2u l=100n
ADFCS_X20_nr_PB0 (x_nor_s0 CI0 pmid_ADFCS_X20_nr_0 VDD) pmos w=2u l=100n
ADFCS_X20_nr_NA0 (x_nor_s0 adfcs_xab VSS VSS) nmos w=1u l=100n
ADFCS_X20_nr_NB0 (x_nor_s0 CI0 VSS VSS) nmos w=1u l=100n
ADFCS_X20_iv_P0 (x_or_s0 x_nor_s0 VDD VDD) pmos w=2u l=100n
ADFCS_X20_iv_N0 (x_or_s0 x_nor_s0 VSS VSS) nmos w=1u l=100n
ADFCS_X20_nd_PA0 (x_nand_s0 adfcs_xab VDD VDD) pmos w=2u l=100n
ADFCS_X20_nd_PB0 (x_nand_s0 CI0 VDD VDD) pmos w=2u l=100n
ADFCS_X20_nd_NB0 (x_nand_s0 CI0 nmid_ADFCS_X20_nd_0 VSS) nmos w=1u l=100n
ADFCS_X20_nd_NA0 (nmid_ADFCS_X20_nd_0 adfcs_xab VSS VSS) nmos w=1u l=100n
ADFCS_X20_na_PA0 (x_pre_s0 x_or_s0 VDD VDD) pmos w=2u l=100n
ADFCS_X20_na_PB0 (x_pre_s0 x_nand_s0 VDD VDD) pmos w=2u l=100n
ADFCS_X20_na_NB0 (x_pre_s0 x_nand_s0 nmid_ADFCS_X20_na_0 VSS) nmos w=1u l=100n
ADFCS_X20_na_NA0 (nmid_ADFCS_X20_na_0 x_or_s0 VSS VSS) nmos w=1u l=100n
ADFCS_X20_xo_P0 (adfcs_s0 x_pre_s0 VDD VDD) pmos w=2u l=100n
ADFCS_X20_xo_N0 (adfcs_s0 x_pre_s0 VSS VSS) nmos w=1u l=100n
ADFCS_X21_nr_PA0 (pmid_ADFCS_X21_nr_0 adfcs_xab VDD VDD) pmos w=2u l=100n
ADFCS_X21_nr_PB0 (x_nor_s1 CI1 pmid_ADFCS_X21_nr_0 VDD) pmos w=2u l=100n
ADFCS_X21_nr_NA0 (x_nor_s1 adfcs_xab VSS VSS) nmos w=1u l=100n
ADFCS_X21_nr_NB0 (x_nor_s1 CI1 VSS VSS) nmos w=1u l=100n
ADFCS_X21_iv_P0 (x_or_s1 x_nor_s1 VDD VDD) pmos w=2u l=100n
ADFCS_X21_iv_N0 (x_or_s1 x_nor_s1 VSS VSS) nmos w=1u l=100n
ADFCS_X21_nd_PA0 (x_nand_s1 adfcs_xab VDD VDD) pmos w=2u l=100n
ADFCS_X21_nd_PB0 (x_nand_s1 CI1 VDD VDD) pmos w=2u l=100n
ADFCS_X21_nd_NB0 (x_nand_s1 CI1 nmid_ADFCS_X21_nd_0 VSS) nmos w=1u l=100n
ADFCS_X21_nd_NA0 (nmid_ADFCS_X21_nd_0 adfcs_xab VSS VSS) nmos w=1u l=100n
ADFCS_X21_na_PA0 (x_pre_s1 x_or_s1 VDD VDD) pmos w=2u l=100n
ADFCS_X21_na_PB0 (x_pre_s1 x_nand_s1 VDD VDD) pmos w=2u l=100n
ADFCS_X21_na_NB0 (x_pre_s1 x_nand_s1 nmid_ADFCS_X21_na_0 VSS) nmos w=1u l=100n
ADFCS_X21_na_NA0 (nmid_ADFCS_X21_na_0 x_or_s1 VSS VSS) nmos w=1u l=100n
ADFCS_X21_xo_P0 (adfcs_s1 x_pre_s1 VDD VDD) pmos w=2u l=100n
ADFCS_X21_xo_N0 (adfcs_s1 x_pre_s1 VSS VSS) nmos w=1u l=100n
ADFCS_CS_P0 (cs_b CS VDD VDD) pmos w=2u l=100n
ADFCS_CS_N0 (cs_b CS VSS VSS) nmos w=1u l=100n
ADFCS_SMUX_MP0 (S CS adfcs_s0 VDD) pmos w=2u l=100n
ADFCS_SMUX_MN0 (S cs_b adfcs_s0 VSS) nmos w=1u l=100n
ADFCS_SMUX_MP1 (S cs_b adfcs_s1 VDD) pmos w=2u l=100n
ADFCS_SMUX_MN1 (S CS adfcs_s1 VSS) nmos w=1u l=100n
ADFCS_AB0_PA0 (adfcs_ab_n0 A VDD VDD) pmos w=2u l=100n
ADFCS_AB0_PB0 (adfcs_ab_n0 B VDD VDD) pmos w=2u l=100n
ADFCS_AB0_NB0 (adfcs_ab_n0 B nmid_ADFCS_AB0_0 VSS) nmos w=1u l=100n
ADFCS_AB0_NA0 (nmid_ADFCS_AB0_0 A VSS VSS) nmos w=1u l=100n
ADFCS_AC0_PA0 (adfcs_ac_n0 A VDD VDD) pmos w=2u l=100n
ADFCS_AC0_PB0 (adfcs_ac_n0 CI0 VDD VDD) pmos w=2u l=100n
ADFCS_AC0_NB0 (adfcs_ac_n0 CI0 nmid_ADFCS_AC0_0 VSS) nmos w=1u l=100n
ADFCS_AC0_NA0 (nmid_ADFCS_AC0_0 A VSS VSS) nmos w=1u l=100n
ADFCS_BC0_PA0 (adfcs_bc_n0 B VDD VDD) pmos w=2u l=100n
ADFCS_BC0_PB0 (adfcs_bc_n0 CI0 VDD VDD) pmos w=2u l=100n
ADFCS_BC0_NB0 (adfcs_bc_n0 CI0 nmid_ADFCS_BC0_0 VSS) nmos w=1u l=100n
ADFCS_BC0_NA0 (nmid_ADFCS_BC0_0 B VSS VSS) nmos w=1u l=100n
ADFCS_ABI0_P0 (adfcs_ab0 adfcs_ab_n0 VDD VDD) pmos w=2u l=100n
ADFCS_ABI0_N0 (adfcs_ab0 adfcs_ab_n0 VSS VSS) nmos w=1u l=100n
ADFCS_ACI0_P0 (adfcs_ac0 adfcs_ac_n0 VDD VDD) pmos w=2u l=100n
ADFCS_ACI0_N0 (adfcs_ac0 adfcs_ac_n0 VSS VSS) nmos w=1u l=100n
ADFCS_BCI0_P0 (adfcs_bc0 adfcs_bc_n0 VDD VDD) pmos w=2u l=100n
ADFCS_BCI0_N0 (adfcs_bc0 adfcs_bc_n0 VSS VSS) nmos w=1u l=100n
ADFCS_OR10_PA0 (pmid_ADFCS_OR10_0 adfcs_ab0 VDD VDD) pmos w=2u l=100n
ADFCS_OR10_PB0 (adfcs_or_n0 adfcs_ac0 pmid_ADFCS_OR10_0 VDD) pmos w=2u l=100n
ADFCS_OR10_NA0 (adfcs_or_n0 adfcs_ab0 VSS VSS) nmos w=1u l=100n
ADFCS_OR10_NB0 (adfcs_or_n0 adfcs_ac0 VSS VSS) nmos w=1u l=100n
ADFCS_OR1I0_P0 (adfcs_or0 adfcs_or_n0 VDD VDD) pmos w=2u l=100n
ADFCS_OR1I0_N0 (adfcs_or0 adfcs_or_n0 VSS VSS) nmos w=1u l=100n
ADFCS_OR20_PA0 (pmid_ADFCS_OR20_0 adfcs_or0 VDD VDD) pmos w=2u l=100n
ADFCS_OR20_PB0 (adfcs_co_n0 adfcs_bc0 pmid_ADFCS_OR20_0 VDD) pmos w=2u l=100n
ADFCS_OR20_NA0 (adfcs_co_n0 adfcs_or0 VSS VSS) nmos w=1u l=100n
ADFCS_OR20_NB0 (adfcs_co_n0 adfcs_bc0 VSS VSS) nmos w=1u l=100n
ADFCS_CO0A_P0 (adfcs_co0 adfcs_co_n0 VDD VDD) pmos w=2u l=100n
ADFCS_CO0A_N0 (adfcs_co0 adfcs_co_n0 VSS VSS) nmos w=1u l=100n
ADFCS_CO0B_P0 (CO0 adfcs_co0 VDD VDD) pmos w=2u l=100n
ADFCS_CO0B_N0 (CO0 adfcs_co0 VSS VSS) nmos w=1u l=100n
ADFCS_AB1_PA0 (adfcs_ab_n1 A VDD VDD) pmos w=2u l=100n
ADFCS_AB1_PB0 (adfcs_ab_n1 B VDD VDD) pmos w=2u l=100n
ADFCS_AB1_NB0 (adfcs_ab_n1 B nmid_ADFCS_AB1_0 VSS) nmos w=1u l=100n
ADFCS_AB1_NA0 (nmid_ADFCS_AB1_0 A VSS VSS) nmos w=1u l=100n
ADFCS_AC1_PA0 (adfcs_ac_n1 A VDD VDD) pmos w=2u l=100n
ADFCS_AC1_PB0 (adfcs_ac_n1 CI1 VDD VDD) pmos w=2u l=100n
ADFCS_AC1_NB0 (adfcs_ac_n1 CI1 nmid_ADFCS_AC1_0 VSS) nmos w=1u l=100n
ADFCS_AC1_NA0 (nmid_ADFCS_AC1_0 A VSS VSS) nmos w=1u l=100n
ADFCS_BC1_PA0 (adfcs_bc_n1 B VDD VDD) pmos w=2u l=100n
ADFCS_BC1_PB0 (adfcs_bc_n1 CI1 VDD VDD) pmos w=2u l=100n
ADFCS_BC1_NB0 (adfcs_bc_n1 CI1 nmid_ADFCS_BC1_0 VSS) nmos w=1u l=100n
ADFCS_BC1_NA0 (nmid_ADFCS_BC1_0 B VSS VSS) nmos w=1u l=100n
ADFCS_ABI1_P0 (adfcs_ab1 adfcs_ab_n1 VDD VDD) pmos w=2u l=100n
ADFCS_ABI1_N0 (adfcs_ab1 adfcs_ab_n1 VSS VSS) nmos w=1u l=100n
ADFCS_ACI1_P0 (adfcs_ac1 adfcs_ac_n1 VDD VDD) pmos w=2u l=100n
ADFCS_ACI1_N0 (adfcs_ac1 adfcs_ac_n1 VSS VSS) nmos w=1u l=100n
ADFCS_BCI1_P0 (adfcs_bc1 adfcs_bc_n1 VDD VDD) pmos w=2u l=100n
ADFCS_BCI1_N0 (adfcs_bc1 adfcs_bc_n1 VSS VSS) nmos w=1u l=100n
ADFCS_OR11_PA0 (pmid_ADFCS_OR11_0 adfcs_ab1 VDD VDD) pmos w=2u l=100n
ADFCS_OR11_PB0 (adfcs_or_n1 adfcs_ac1 pmid_ADFCS_OR11_0 VDD) pmos w=2u l=100n
ADFCS_OR11_NA0 (adfcs_or_n1 adfcs_ab1 VSS VSS) nmos w=1u l=100n
ADFCS_OR11_NB0 (adfcs_or_n1 adfcs_ac1 VSS VSS) nmos w=1u l=100n
ADFCS_OR1I1_P0 (adfcs_or1 adfcs_or_n1 VDD VDD) pmos w=2u l=100n
ADFCS_OR1I1_N0 (adfcs_or1 adfcs_or_n1 VSS VSS) nmos w=1u l=100n
ADFCS_OR21_PA0 (pmid_ADFCS_OR21_0 adfcs_or1 VDD VDD) pmos w=2u l=100n
ADFCS_OR21_PB0 (adfcs_co_n1 adfcs_bc1 pmid_ADFCS_OR21_0 VDD) pmos w=2u l=100n
ADFCS_OR21_NA0 (adfcs_co_n1 adfcs_or1 VSS VSS) nmos w=1u l=100n
ADFCS_OR21_NB0 (adfcs_co_n1 adfcs_bc1 VSS VSS) nmos w=1u l=100n
ADFCS_CO1A_P0 (adfcs_co1 adfcs_co_n1 VDD VDD) pmos w=2u l=100n
ADFCS_CO1A_N0 (adfcs_co1 adfcs_co_n1 VSS VSS) nmos w=1u l=100n
ADFCS_CO1B_P0 (CO1 adfcs_co1 VDD VDD) pmos w=2u l=100n
ADFCS_CO1B_N0 (CO1 adfcs_co1 VSS VSS) nmos w=1u l=100n
ends addfcscoi_x1
