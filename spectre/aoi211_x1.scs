subckt aoi211_x1 A1 A2 B1 B2 X VDD VSS
MNA10 (X A1 aoi211_nsa VSS) nmos w=1u l=100n
MNA20 (aoi211_nsa A2 VSS VSS) nmos w=1u l=100n
MNB0 (X B1 VSS VSS) nmos w=1u l=100n
MNC0 (X B2 VSS VSS) nmos w=1u l=100n
MPC0 (aoi211_n2 B2 VDD VDD) pmos w=2u l=100n
MPB0 (aoi211_n1 B1 aoi211_n2 VDD) pmos w=2u l=100n
MPA10 (X A1 aoi211_n1 VDD) pmos w=2u l=100n
MPA20 (X A2 aoi211_n1 VDD) pmos w=2u l=100n
ends aoi211_x1
