subckt fdnrbq_x1 Q CK D RD VDD VSS
FDNRBQ_ck_P0 (FDNRBQ_ck_b CK VDD VDD) pmos w=2u l=100n
FDNRBQ_ck_N0 (FDNRBQ_ck_b CK VSS VSS) nmos w=1u l=100n
FDNRBQ_m_in_P (FDNRBQ_m_n1 FDNRBQ_ck_b D VDD) pmos w=2u l=100n
FDNRBQ_m_in_N (FDNRBQ_m_n1 CK D VSS) nmos w=1u l=100n
FDNRBQ_m_i1_P0 (FDNRBQ_m_n2 FDNRBQ_m_n1 VDD VDD) pmos w=2u l=100n
FDNRBQ_m_i1_N0 (FDNRBQ_m_n2 FDNRBQ_m_n1 VSS VSS) nmos w=1u l=100n
FDNRBQ_m_i2_P0 (FDNRBQ_m_n1 FDNRBQ_m_n2 VDD VDD) pmos w=2u l=100n
FDNRBQ_m_i2_N0 (FDNRBQ_m_n1 FDNRBQ_m_n2 VSS VSS) nmos w=1u l=100n
FDNRBQ_m_fb_P (FDNRBQ_m_n1 CK FDNRBQ_m_n2 VDD) pmos w=2u l=100n
FDNRBQ_m_fb_N (FDNRBQ_m_n1 FDNRBQ_ck_b FDNRBQ_m_n2 VSS) nmos w=1u l=100n
FDNRBQ_m_o_P0 (FDNRBQ_qm FDNRBQ_m_n2 VDD VDD) pmos w=2u l=100n
FDNRBQ_m_o_N0 (FDNRBQ_qm FDNRBQ_m_n2 VSS VSS) nmos w=1u l=100n
FDNRBQ_s_in_P (FDNRBQ_s_n1 CK FDNRBQ_qm VDD) pmos w=2u l=100n
FDNRBQ_s_in_N (FDNRBQ_s_n1 FDNRBQ_ck_b FDNRBQ_qm VSS) nmos w=1u l=100n
FDNRBQ_s_i1_P0 (FDNRBQ_s_n2 FDNRBQ_s_n1 VDD VDD) pmos w=2u l=100n
FDNRBQ_s_i1_N0 (FDNRBQ_s_n2 FDNRBQ_s_n1 VSS VSS) nmos w=1u l=100n
FDNRBQ_s_i2_P0 (FDNRBQ_s_n1 FDNRBQ_s_n2 VDD VDD) pmos w=2u l=100n
FDNRBQ_s_i2_N0 (FDNRBQ_s_n1 FDNRBQ_s_n2 VSS VSS) nmos w=1u l=100n
FDNRBQ_s_fb_P (FDNRBQ_s_n1 FDNRBQ_ck_b FDNRBQ_s_n2 VDD) pmos w=2u l=100n
FDNRBQ_s_fb_N (FDNRBQ_s_n1 CK FDNRBQ_s_n2 VSS) nmos w=1u l=100n
FDNRBQ_s_o_P0 (Q FDNRBQ_s_n2 VDD VDD) pmos w=2u l=100n
FDNRBQ_s_o_N0 (Q FDNRBQ_s_n2 VSS VSS) nmos w=1u l=100n
FDNRBQ_rdi_P0 (FDNRBQ_rd_b RD VDD VDD) pmos w=2u l=100n
FDNRBQ_rdi_N0 (FDNRBQ_rd_b RD VSS VSS) nmos w=1u l=100n
FDNRBQ_rcl (Q FDNRBQ_rd_b VSS VSS) nmos w=1u l=100n
ends fdnrbq_x1
