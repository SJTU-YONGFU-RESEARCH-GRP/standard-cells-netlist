subckt oa31_x1 A1 A2 B1 B2 X VDD VSS
* Abstract subckt: behavioral/LVS placeholder — no MOS instances in the template.
ends oa31_x1
