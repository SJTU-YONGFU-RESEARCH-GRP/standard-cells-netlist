subckt oa31_x1 A1 A2 B1 B2 X VDD VSS
OA31N30_PA0 (pmid1 A1 VDD VDD) pmos w=2u l=100n
OA31N30_PB0 (pmid2 A2 pmid1 VDD) pmos w=2u l=100n
OA31N30_PC0 (oa31_or_n B1 pmid2 VDD) pmos w=2u l=100n
OA31N30_NA0 (oa31_or_n A1 VSS VSS) nmos w=1u l=100n
OA31N30_NB0 (oa31_or_n A2 VSS VSS) nmos w=1u l=100n
OA31N30_NC0 (oa31_or_n B1 VSS VSS) nmos w=1u l=100n
OA31I30_P0 (oa31_or oa31_or_n VDD VDD) pmos w=2u l=100n
OA31I30_N0 (oa31_or oa31_or_n VSS VSS) nmos w=1u l=100n
OA31N20_PA0 (oa31_and_n oa31_or VDD VDD) pmos w=2u l=100n
OA31N20_PB0 (oa31_and_n B2 VDD VDD) pmos w=2u l=100n
OA31N20_NB0 (oa31_and_n B2 nmid_OA31N20_0 VSS) nmos w=1u l=100n
OA31N20_NA0 (nmid_OA31N20_0 oa31_or VSS VSS) nmos w=1u l=100n
OA31O0_P0 (X oa31_and_n VDD VDD) pmos w=2u l=100n
OA31O0_N0 (X oa31_and_n VSS VSS) nmos w=1u l=100n
ends oa31_x1
