subckt nand3i_x1 A B1 B2 X VDD VSS
M0I_P0 (in0_b A VDD VDD) pmos w=2u l=100n
M0I_N0 (in0_b A VSS VSS) nmos w=1u l=100n
MPA0 (X in0_b VDD VDD) pmos w=2u l=100n
MPB0 (X B1 VDD VDD) pmos w=2u l=100n
MPC0 (X B2 VDD VDD) pmos w=2u l=100n
MNC0 (X B2 nmid2 VSS) nmos w=1u l=100n
MNB0 (nmid2 B1 nmid1 VSS) nmos w=1u l=100n
MNA0 (nmid1 in0_b VSS VSS) nmos w=1u l=100n
ends nand3i_x1
