subckt aoi22_x1 A1 A2 B1 B2 X VDD VSS
MNA10 (X A1 aoi22_nsa VSS) nmos w=1u l=100n
MNA20 (aoi22_nsa A2 VSS VSS) nmos w=1u l=100n
MNB10 (X B1 aoi22_nsb VSS) nmos w=1u l=100n
MNB20 (aoi22_nsb B2 VSS VSS) nmos w=1u l=100n
MPA10 (aoi22_n1 A1 VDD VDD) pmos w=2u l=100n
MPA20 (aoi22_n1 A2 VDD VDD) pmos w=2u l=100n
MPB10 (X B1 aoi22_n1 VDD) pmos w=2u l=100n
MPB20 (X B2 aoi22_n1 VDD) pmos w=2u l=100n
ends aoi22_x1
