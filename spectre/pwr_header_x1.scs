subckt pwr_header_x1 VDD VDDH VSS
* Power rail / header / footer / PM cell: VDD (core), VDDH (domain/I/O), VSS.
ends pwr_header_x1
