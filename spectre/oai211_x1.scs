subckt oai211_x1 A1 A2 B1 B2 X VDD VSS
MNA10 (X A1 oai211_n1 VSS) nmos w=1u l=100n
MNA20 (X A2 oai211_n1 VSS) nmos w=1u l=100n
MNB0 (oai211_n1 B1 oai211_n2 VSS) nmos w=1u l=100n
MNC0 (oai211_n2 B2 VSS VSS) nmos w=1u l=100n
MPA10 (oai211_p1a A1 VDD VDD) pmos w=2u l=100n
MPA20 (X A2 oai211_p1a VDD) pmos w=2u l=100n
MPB0 (X B1 VDD VDD) pmos w=2u l=100n
MPC0 (X B2 VDD VDD) pmos w=2u l=100n
ends oai211_x1
