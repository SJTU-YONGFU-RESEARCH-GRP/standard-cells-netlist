subckt tiehi_x1 X VDD VSS
* Physical cell: abstract subckt (rails per PDK CDL; add PDK devices if needed).
TIE1P (X VSS VDD VDD) pmos w=2u l=100n
ends tiehi_x1
