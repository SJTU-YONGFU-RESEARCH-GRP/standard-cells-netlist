subckt addfcoi_x1 S CO A B CI VDD VSS
ADDF_X1_nr_PA0 (pmid_ADDF_X1_nr_0 A VDD VDD) pmos w=2u l=100n
ADDF_X1_nr_PB0 (x_nor_ab B pmid_ADDF_X1_nr_0 VDD) pmos w=2u l=100n
ADDF_X1_nr_NA0 (x_nor_ab A VSS VSS) nmos w=1u l=100n
ADDF_X1_nr_NB0 (x_nor_ab B VSS VSS) nmos w=1u l=100n
ADDF_X1_iv_P0 (x_or_ab x_nor_ab VDD VDD) pmos w=2u l=100n
ADDF_X1_iv_N0 (x_or_ab x_nor_ab VSS VSS) nmos w=1u l=100n
ADDF_X1_nd_PA0 (x_nand_ab A VDD VDD) pmos w=2u l=100n
ADDF_X1_nd_PB0 (x_nand_ab B VDD VDD) pmos w=2u l=100n
ADDF_X1_nd_NB0 (x_nand_ab B nmid_ADDF_X1_nd_0 VSS) nmos w=1u l=100n
ADDF_X1_nd_NA0 (nmid_ADDF_X1_nd_0 A VSS VSS) nmos w=1u l=100n
ADDF_X1_na_PA0 (x_pre_ab x_or_ab VDD VDD) pmos w=2u l=100n
ADDF_X1_na_PB0 (x_pre_ab x_nand_ab VDD VDD) pmos w=2u l=100n
ADDF_X1_na_NB0 (x_pre_ab x_nand_ab nmid_ADDF_X1_na_0 VSS) nmos w=1u l=100n
ADDF_X1_na_NA0 (nmid_ADDF_X1_na_0 x_or_ab VSS VSS) nmos w=1u l=100n
ADDF_X1_xo_P0 (addf_xab x_pre_ab VDD VDD) pmos w=2u l=100n
ADDF_X1_xo_N0 (addf_xab x_pre_ab VSS VSS) nmos w=1u l=100n
ADDF_X2_nr_PA0 (pmid_ADDF_X2_nr_0 addf_xab VDD VDD) pmos w=2u l=100n
ADDF_X2_nr_PB0 (x_nor_s CI pmid_ADDF_X2_nr_0 VDD) pmos w=2u l=100n
ADDF_X2_nr_NA0 (x_nor_s addf_xab VSS VSS) nmos w=1u l=100n
ADDF_X2_nr_NB0 (x_nor_s CI VSS VSS) nmos w=1u l=100n
ADDF_X2_iv_P0 (x_or_s x_nor_s VDD VDD) pmos w=2u l=100n
ADDF_X2_iv_N0 (x_or_s x_nor_s VSS VSS) nmos w=1u l=100n
ADDF_X2_nd_PA0 (x_nand_s addf_xab VDD VDD) pmos w=2u l=100n
ADDF_X2_nd_PB0 (x_nand_s CI VDD VDD) pmos w=2u l=100n
ADDF_X2_nd_NB0 (x_nand_s CI nmid_ADDF_X2_nd_0 VSS) nmos w=1u l=100n
ADDF_X2_nd_NA0 (nmid_ADDF_X2_nd_0 addf_xab VSS VSS) nmos w=1u l=100n
ADDF_X2_na_PA0 (x_pre_s x_or_s VDD VDD) pmos w=2u l=100n
ADDF_X2_na_PB0 (x_pre_s x_nand_s VDD VDD) pmos w=2u l=100n
ADDF_X2_na_NB0 (x_pre_s x_nand_s nmid_ADDF_X2_na_0 VSS) nmos w=1u l=100n
ADDF_X2_na_NA0 (nmid_ADDF_X2_na_0 x_or_s VSS VSS) nmos w=1u l=100n
ADDF_X2_xo_P0 (S x_pre_s VDD VDD) pmos w=2u l=100n
ADDF_X2_xo_N0 (S x_pre_s VSS VSS) nmos w=1u l=100n
ADDF_AB_PA0 (addf_ab_n A VDD VDD) pmos w=2u l=100n
ADDF_AB_PB0 (addf_ab_n B VDD VDD) pmos w=2u l=100n
ADDF_AB_NB0 (addf_ab_n B nmid_ADDF_AB_0 VSS) nmos w=1u l=100n
ADDF_AB_NA0 (nmid_ADDF_AB_0 A VSS VSS) nmos w=1u l=100n
ADDF_AC_PA0 (addf_ac_n A VDD VDD) pmos w=2u l=100n
ADDF_AC_PB0 (addf_ac_n CI VDD VDD) pmos w=2u l=100n
ADDF_AC_NB0 (addf_ac_n CI nmid_ADDF_AC_0 VSS) nmos w=1u l=100n
ADDF_AC_NA0 (nmid_ADDF_AC_0 A VSS VSS) nmos w=1u l=100n
ADDF_BC_PA0 (addf_bc_n B VDD VDD) pmos w=2u l=100n
ADDF_BC_PB0 (addf_bc_n CI VDD VDD) pmos w=2u l=100n
ADDF_BC_NB0 (addf_bc_n CI nmid_ADDF_BC_0 VSS) nmos w=1u l=100n
ADDF_BC_NA0 (nmid_ADDF_BC_0 B VSS VSS) nmos w=1u l=100n
ADDF_ABI_P0 (addf_ab addf_ab_n VDD VDD) pmos w=2u l=100n
ADDF_ABI_N0 (addf_ab addf_ab_n VSS VSS) nmos w=1u l=100n
ADDF_ACI_P0 (addf_ac addf_ac_n VDD VDD) pmos w=2u l=100n
ADDF_ACI_N0 (addf_ac addf_ac_n VSS VSS) nmos w=1u l=100n
ADDF_BCI_P0 (addf_bc addf_bc_n VDD VDD) pmos w=2u l=100n
ADDF_BCI_N0 (addf_bc addf_bc_n VSS VSS) nmos w=1u l=100n
ADDF_OR1_PA0 (pmid_ADDF_OR1_0 addf_ab VDD VDD) pmos w=2u l=100n
ADDF_OR1_PB0 (addf_or_n addf_ac pmid_ADDF_OR1_0 VDD) pmos w=2u l=100n
ADDF_OR1_NA0 (addf_or_n addf_ab VSS VSS) nmos w=1u l=100n
ADDF_OR1_NB0 (addf_or_n addf_ac VSS VSS) nmos w=1u l=100n
ADDF_OR1I_P0 (addf_or addf_or_n VDD VDD) pmos w=2u l=100n
ADDF_OR1I_N0 (addf_or addf_or_n VSS VSS) nmos w=1u l=100n
ADDF_OR2_PA0 (pmid_ADDF_OR2_0 addf_or VDD VDD) pmos w=2u l=100n
ADDF_OR2_PB0 (addf_co_n addf_bc pmid_ADDF_OR2_0 VDD) pmos w=2u l=100n
ADDF_OR2_NA0 (addf_co_n addf_or VSS VSS) nmos w=1u l=100n
ADDF_OR2_NB0 (addf_co_n addf_bc VSS VSS) nmos w=1u l=100n
ADDF_COI_A_P0 (addf_co addf_co_n VDD VDD) pmos w=2u l=100n
ADDF_COI_A_N0 (addf_co addf_co_n VSS VSS) nmos w=1u l=100n
ADDF_COI_B_P0 (CO addf_co VDD VDD) pmos w=2u l=100n
ADDF_COI_B_N0 (CO addf_co VSS VSS) nmos w=1u l=100n
ends addfcoi_x1
