subckt addfcoi_x1 S CO A B CI VDD VSS
* Abstract subckt: behavioral/LVS placeholder — no MOS instances in the template.
ends addfcoi_x1
