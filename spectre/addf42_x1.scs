subckt addf42_x1 S CO ICO A B C D CI VDD VSS
A42_X1_nr_PA0 (pmid_A42_X1_nr_0 A VDD VDD) pmos w=2u l=100n
A42_X1_nr_PB0 (x_nor_ab B pmid_A42_X1_nr_0 VDD) pmos w=2u l=100n
A42_X1_nr_NA0 (x_nor_ab A VSS VSS) nmos w=1u l=100n
A42_X1_nr_NB0 (x_nor_ab B VSS VSS) nmos w=1u l=100n
A42_X1_iv_P0 (x_or_ab x_nor_ab VDD VDD) pmos w=2u l=100n
A42_X1_iv_N0 (x_or_ab x_nor_ab VSS VSS) nmos w=1u l=100n
A42_X1_nd_PA0 (x_nand_ab A VDD VDD) pmos w=2u l=100n
A42_X1_nd_PB0 (x_nand_ab B VDD VDD) pmos w=2u l=100n
A42_X1_nd_NB0 (x_nand_ab B nmid_A42_X1_nd_0 VSS) nmos w=1u l=100n
A42_X1_nd_NA0 (nmid_A42_X1_nd_0 A VSS VSS) nmos w=1u l=100n
A42_X1_na_PA0 (x_pre_ab x_or_ab VDD VDD) pmos w=2u l=100n
A42_X1_na_PB0 (x_pre_ab x_nand_ab VDD VDD) pmos w=2u l=100n
A42_X1_na_NB0 (x_pre_ab x_nand_ab nmid_A42_X1_na_0 VSS) nmos w=1u l=100n
A42_X1_na_NA0 (nmid_A42_X1_na_0 x_or_ab VSS VSS) nmos w=1u l=100n
A42_X1_xo_P0 (a42_xab x_pre_ab VDD VDD) pmos w=2u l=100n
A42_X1_xo_N0 (a42_xab x_pre_ab VSS VSS) nmos w=1u l=100n
A42_X2_nr_PA0 (pmid_A42_X2_nr_0 a42_xab VDD VDD) pmos w=2u l=100n
A42_X2_nr_PB0 (x_nor_abc C pmid_A42_X2_nr_0 VDD) pmos w=2u l=100n
A42_X2_nr_NA0 (x_nor_abc a42_xab VSS VSS) nmos w=1u l=100n
A42_X2_nr_NB0 (x_nor_abc C VSS VSS) nmos w=1u l=100n
A42_X2_iv_P0 (x_or_abc x_nor_abc VDD VDD) pmos w=2u l=100n
A42_X2_iv_N0 (x_or_abc x_nor_abc VSS VSS) nmos w=1u l=100n
A42_X2_nd_PA0 (x_nand_abc a42_xab VDD VDD) pmos w=2u l=100n
A42_X2_nd_PB0 (x_nand_abc C VDD VDD) pmos w=2u l=100n
A42_X2_nd_NB0 (x_nand_abc C nmid_A42_X2_nd_0 VSS) nmos w=1u l=100n
A42_X2_nd_NA0 (nmid_A42_X2_nd_0 a42_xab VSS VSS) nmos w=1u l=100n
A42_X2_na_PA0 (x_pre_abc x_or_abc VDD VDD) pmos w=2u l=100n
A42_X2_na_PB0 (x_pre_abc x_nand_abc VDD VDD) pmos w=2u l=100n
A42_X2_na_NB0 (x_pre_abc x_nand_abc nmid_A42_X2_na_0 VSS) nmos w=1u l=100n
A42_X2_na_NA0 (nmid_A42_X2_na_0 x_or_abc VSS VSS) nmos w=1u l=100n
A42_X2_xo_P0 (a42_xabc x_pre_abc VDD VDD) pmos w=2u l=100n
A42_X2_xo_N0 (a42_xabc x_pre_abc VSS VSS) nmos w=1u l=100n
A42_X3_nr_PA0 (pmid_A42_X3_nr_0 a42_xabc VDD VDD) pmos w=2u l=100n
A42_X3_nr_PB0 (x_nor_sum D pmid_A42_X3_nr_0 VDD) pmos w=2u l=100n
A42_X3_nr_NA0 (x_nor_sum a42_xabc VSS VSS) nmos w=1u l=100n
A42_X3_nr_NB0 (x_nor_sum D VSS VSS) nmos w=1u l=100n
A42_X3_iv_P0 (x_or_sum x_nor_sum VDD VDD) pmos w=2u l=100n
A42_X3_iv_N0 (x_or_sum x_nor_sum VSS VSS) nmos w=1u l=100n
A42_X3_nd_PA0 (x_nand_sum a42_xabc VDD VDD) pmos w=2u l=100n
A42_X3_nd_PB0 (x_nand_sum D VDD VDD) pmos w=2u l=100n
A42_X3_nd_NB0 (x_nand_sum D nmid_A42_X3_nd_0 VSS) nmos w=1u l=100n
A42_X3_nd_NA0 (nmid_A42_X3_nd_0 a42_xabc VSS VSS) nmos w=1u l=100n
A42_X3_na_PA0 (x_pre_sum x_or_sum VDD VDD) pmos w=2u l=100n
A42_X3_na_PB0 (x_pre_sum x_nand_sum VDD VDD) pmos w=2u l=100n
A42_X3_na_NB0 (x_pre_sum x_nand_sum nmid_A42_X3_na_0 VSS) nmos w=1u l=100n
A42_X3_na_NA0 (nmid_A42_X3_na_0 x_or_sum VSS VSS) nmos w=1u l=100n
A42_X3_xo_P0 (a42_xabcd x_pre_sum VDD VDD) pmos w=2u l=100n
A42_X3_xo_N0 (a42_xabcd x_pre_sum VSS VSS) nmos w=1u l=100n
A42_X4_nr_PA0 (pmid_A42_X4_nr_0 a42_xabcd VDD VDD) pmos w=2u l=100n
A42_X4_nr_PB0 (x_nor_sum2 CI pmid_A42_X4_nr_0 VDD) pmos w=2u l=100n
A42_X4_nr_NA0 (x_nor_sum2 a42_xabcd VSS VSS) nmos w=1u l=100n
A42_X4_nr_NB0 (x_nor_sum2 CI VSS VSS) nmos w=1u l=100n
A42_X4_iv_P0 (x_or_sum2 x_nor_sum2 VDD VDD) pmos w=2u l=100n
A42_X4_iv_N0 (x_or_sum2 x_nor_sum2 VSS VSS) nmos w=1u l=100n
A42_X4_nd_PA0 (x_nand_sum2 a42_xabcd VDD VDD) pmos w=2u l=100n
A42_X4_nd_PB0 (x_nand_sum2 CI VDD VDD) pmos w=2u l=100n
A42_X4_nd_NB0 (x_nand_sum2 CI nmid_A42_X4_nd_0 VSS) nmos w=1u l=100n
A42_X4_nd_NA0 (nmid_A42_X4_nd_0 a42_xabcd VSS VSS) nmos w=1u l=100n
A42_X4_na_PA0 (x_pre_sum2 x_or_sum2 VDD VDD) pmos w=2u l=100n
A42_X4_na_PB0 (x_pre_sum2 x_nand_sum2 VDD VDD) pmos w=2u l=100n
A42_X4_na_NB0 (x_pre_sum2 x_nand_sum2 nmid_A42_X4_na_0 VSS) nmos w=1u l=100n
A42_X4_na_NA0 (nmid_A42_X4_na_0 x_or_sum2 VSS VSS) nmos w=1u l=100n
A42_X4_xo_P0 (S x_pre_sum2 VDD VDD) pmos w=2u l=100n
A42_X4_xo_N0 (S x_pre_sum2 VSS VSS) nmos w=1u l=100n
A42_AB_PA0 (a42_ab_n A VDD VDD) pmos w=2u l=100n
A42_AB_PB0 (a42_ab_n B VDD VDD) pmos w=2u l=100n
A42_AB_NB0 (a42_ab_n B nmid_A42_AB_0 VSS) nmos w=1u l=100n
A42_AB_NA0 (nmid_A42_AB_0 A VSS VSS) nmos w=1u l=100n
A42_AC_PA0 (a42_ac_n A VDD VDD) pmos w=2u l=100n
A42_AC_PB0 (a42_ac_n C VDD VDD) pmos w=2u l=100n
A42_AC_NB0 (a42_ac_n C nmid_A42_AC_0 VSS) nmos w=1u l=100n
A42_AC_NA0 (nmid_A42_AC_0 A VSS VSS) nmos w=1u l=100n
A42_BC_PA0 (a42_bc_n B VDD VDD) pmos w=2u l=100n
A42_BC_PB0 (a42_bc_n C VDD VDD) pmos w=2u l=100n
A42_BC_NB0 (a42_bc_n C nmid_A42_BC_0 VSS) nmos w=1u l=100n
A42_BC_NA0 (nmid_A42_BC_0 B VSS VSS) nmos w=1u l=100n
A42_ABI_P0 (a42_ab a42_ab_n VDD VDD) pmos w=2u l=100n
A42_ABI_N0 (a42_ab a42_ab_n VSS VSS) nmos w=1u l=100n
A42_ACI_P0 (a42_ac a42_ac_n VDD VDD) pmos w=2u l=100n
A42_ACI_N0 (a42_ac a42_ac_n VSS VSS) nmos w=1u l=100n
A42_BCI_P0 (a42_bc a42_bc_n VDD VDD) pmos w=2u l=100n
A42_BCI_N0 (a42_bc a42_bc_n VSS VSS) nmos w=1u l=100n
A42_ICO1_PA0 (pmid_A42_ICO1_0 a42_ab VDD VDD) pmos w=2u l=100n
A42_ICO1_PB0 (a42_ico_or_n a42_ac pmid_A42_ICO1_0 VDD) pmos w=2u l=100n
A42_ICO1_NA0 (a42_ico_or_n a42_ab VSS VSS) nmos w=1u l=100n
A42_ICO1_NB0 (a42_ico_or_n a42_ac VSS VSS) nmos w=1u l=100n
A42_ICO1I_P0 (a42_ico_or a42_ico_or_n VDD VDD) pmos w=2u l=100n
A42_ICO1I_N0 (a42_ico_or a42_ico_or_n VSS VSS) nmos w=1u l=100n
A42_ICO2_PA0 (pmid_A42_ICO2_0 a42_ico_or VDD VDD) pmos w=2u l=100n
A42_ICO2_PB0 (a42_ico_n a42_bc pmid_A42_ICO2_0 VDD) pmos w=2u l=100n
A42_ICO2_NA0 (a42_ico_n a42_ico_or VSS VSS) nmos w=1u l=100n
A42_ICO2_NB0 (a42_ico_n a42_bc VSS VSS) nmos w=1u l=100n
A42_ICO_P0 (ICO a42_ico_n VDD VDD) pmos w=2u l=100n
A42_ICO_N0 (ICO a42_ico_n VSS VSS) nmos w=1u l=100n
A42_PD_PA0 (a42_pd_n a42_xabc VDD VDD) pmos w=2u l=100n
A42_PD_PB0 (a42_pd_n D VDD VDD) pmos w=2u l=100n
A42_PD_NB0 (a42_pd_n D nmid_A42_PD_0 VSS) nmos w=1u l=100n
A42_PD_NA0 (nmid_A42_PD_0 a42_xabc VSS VSS) nmos w=1u l=100n
A42_PC_PA0 (a42_pc_n a42_xabc VDD VDD) pmos w=2u l=100n
A42_PC_PB0 (a42_pc_n CI VDD VDD) pmos w=2u l=100n
A42_PC_NB0 (a42_pc_n CI nmid_A42_PC_0 VSS) nmos w=1u l=100n
A42_PC_NA0 (nmid_A42_PC_0 a42_xabc VSS VSS) nmos w=1u l=100n
A42_DC_PA0 (a42_dc_n D VDD VDD) pmos w=2u l=100n
A42_DC_PB0 (a42_dc_n CI VDD VDD) pmos w=2u l=100n
A42_DC_NB0 (a42_dc_n CI nmid_A42_DC_0 VSS) nmos w=1u l=100n
A42_DC_NA0 (nmid_A42_DC_0 D VSS VSS) nmos w=1u l=100n
A42_PDI_P0 (a42_pd a42_pd_n VDD VDD) pmos w=2u l=100n
A42_PDI_N0 (a42_pd a42_pd_n VSS VSS) nmos w=1u l=100n
A42_PCI_P0 (a42_pc a42_pc_n VDD VDD) pmos w=2u l=100n
A42_PCI_N0 (a42_pc a42_pc_n VSS VSS) nmos w=1u l=100n
A42_DCI_P0 (a42_dc a42_dc_n VDD VDD) pmos w=2u l=100n
A42_DCI_N0 (a42_dc a42_dc_n VSS VSS) nmos w=1u l=100n
A42_CO1_PA0 (pmid_A42_CO1_0 a42_pd VDD VDD) pmos w=2u l=100n
A42_CO1_PB0 (a42_co_or_n a42_pc pmid_A42_CO1_0 VDD) pmos w=2u l=100n
A42_CO1_NA0 (a42_co_or_n a42_pd VSS VSS) nmos w=1u l=100n
A42_CO1_NB0 (a42_co_or_n a42_pc VSS VSS) nmos w=1u l=100n
A42_CO1I_P0 (a42_co_or a42_co_or_n VDD VDD) pmos w=2u l=100n
A42_CO1I_N0 (a42_co_or a42_co_or_n VSS VSS) nmos w=1u l=100n
A42_CO2_PA0 (pmid_A42_CO2_0 a42_co_or VDD VDD) pmos w=2u l=100n
A42_CO2_PB0 (a42_co_n a42_dc pmid_A42_CO2_0 VDD) pmos w=2u l=100n
A42_CO2_NA0 (a42_co_n a42_co_or VSS VSS) nmos w=1u l=100n
A42_CO2_NB0 (a42_co_n a42_dc VSS VSS) nmos w=1u l=100n
A42_CO_P0 (CO a42_co_n VDD VDD) pmos w=2u l=100n
A42_CO_N0 (CO a42_co_n VSS VSS) nmos w=1u l=100n
ends addf42_x1
