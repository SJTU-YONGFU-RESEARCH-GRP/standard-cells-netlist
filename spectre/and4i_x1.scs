subckt and4i_x1 A B1 B2 B3 X VDD VSS
A4I_P0 (in0_b A VDD VDD) pmos w=2u l=100n
A4I_N0 (in0_b A VSS VSS) nmos w=1u l=100n
A4I0_PA0 (nand4i_out in0_b VDD VDD) pmos w=2u l=100n
A4I0_PB0 (nand4i_out B1 VDD VDD) pmos w=2u l=100n
A4I0_PC0 (nand4i_out B2 VDD VDD) pmos w=2u l=100n
A4I0_PD0 (nand4i_out B3 VDD VDD) pmos w=2u l=100n
A4I0_ND0 (nand4i_out B3 na4_3 VSS) nmos w=1u l=100n
A4I0_NC0 (na4_3 B2 na4_2 VSS) nmos w=1u l=100n
A4I0_NB0 (na4_2 B1 na4_1 VSS) nmos w=1u l=100n
A4I0_NA0 (na4_1 in0_b VSS VSS) nmos w=1u l=100n
A4II0_P0 (X nand4i_out VDD VDD) pmos w=2u l=100n
A4II0_N0 (X nand4i_out VSS VSS) nmos w=1u l=100n
ends and4i_x1
