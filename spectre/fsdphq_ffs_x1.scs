subckt fsdphq_ffs_x1 Q CK D SI SE EN VDD VSS
* Abstract subckt (no MOS instances).
* ref_lib analogue: provide a PDK-specific transistor netlist if needed.
* Use verilog/vhdl for functional simulation; provide a PDK-specific netlist for transistor-level.
ends fsdphq_ffs_x1
