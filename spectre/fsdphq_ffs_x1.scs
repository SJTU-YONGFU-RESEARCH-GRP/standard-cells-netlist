subckt fsdphq_ffs_x1 Q CK D SI SE EN VDD VSS
FSDPHQ_FFS_sei_P0 (FSDPHQ_FFS_se_b SE VDD VDD) pmos w=2u l=100n
FSDPHQ_FFS_sei_N0 (FSDPHQ_FFS_se_b SE VSS VSS) nmos w=1u l=100n
FSDPHQ_FFS_smx_MP0 (FSDPHQ_FFS_din SE D VDD) pmos w=2u l=100n
FSDPHQ_FFS_smx_MN0 (FSDPHQ_FFS_din FSDPHQ_FFS_se_b D VSS) nmos w=1u l=100n
FSDPHQ_FFS_smx_MP1 (FSDPHQ_FFS_din FSDPHQ_FFS_se_b SI VDD) pmos w=2u l=100n
FSDPHQ_FFS_smx_MN1 (FSDPHQ_FFS_din SE SI VSS) nmos w=1u l=100n
FSDPHQ_FFS_eni_P0 (FSDPHQ_FFS_en_b EN VDD VDD) pmos w=2u l=100n
FSDPHQ_FFS_eni_N0 (FSDPHQ_FFS_en_b EN VSS VSS) nmos w=1u l=100n
FSDPHQ_FFS_emx_MP0 (FSDPHQ_FFS_ed EN Q VDD) pmos w=2u l=100n
FSDPHQ_FFS_emx_MN0 (FSDPHQ_FFS_ed FSDPHQ_FFS_en_b Q VSS) nmos w=1u l=100n
FSDPHQ_FFS_emx_MP1 (FSDPHQ_FFS_ed FSDPHQ_FFS_en_b FSDPHQ_FFS_din VDD) pmos w=2u l=100n
FSDPHQ_FFS_emx_MN1 (FSDPHQ_FFS_ed EN FSDPHQ_FFS_din VSS) nmos w=1u l=100n
FSDPHQ_FFS_ck_P0 (FSDPHQ_FFS_ck_b CK VDD VDD) pmos w=2u l=100n
FSDPHQ_FFS_ck_N0 (FSDPHQ_FFS_ck_b CK VSS VSS) nmos w=1u l=100n
FSDPHQ_FFS_m_in_P (FSDPHQ_FFS_m_n1 CK FSDPHQ_FFS_ed VDD) pmos w=2u l=100n
FSDPHQ_FFS_m_in_N (FSDPHQ_FFS_m_n1 FSDPHQ_FFS_ck_b FSDPHQ_FFS_ed VSS) nmos w=1u l=100n
FSDPHQ_FFS_m_i1_P0 (FSDPHQ_FFS_m_n2 FSDPHQ_FFS_m_n1 VDD VDD) pmos w=2u l=100n
FSDPHQ_FFS_m_i1_N0 (FSDPHQ_FFS_m_n2 FSDPHQ_FFS_m_n1 VSS VSS) nmos w=1u l=100n
FSDPHQ_FFS_m_i2_P0 (FSDPHQ_FFS_m_n1 FSDPHQ_FFS_m_n2 VDD VDD) pmos w=2u l=100n
FSDPHQ_FFS_m_i2_N0 (FSDPHQ_FFS_m_n1 FSDPHQ_FFS_m_n2 VSS VSS) nmos w=1u l=100n
FSDPHQ_FFS_m_fb_P (FSDPHQ_FFS_m_n1 FSDPHQ_FFS_ck_b FSDPHQ_FFS_m_n2 VDD) pmos w=2u l=100n
FSDPHQ_FFS_m_fb_N (FSDPHQ_FFS_m_n1 CK FSDPHQ_FFS_m_n2 VSS) nmos w=1u l=100n
FSDPHQ_FFS_m_o_P0 (FSDPHQ_FFS_qm FSDPHQ_FFS_m_n2 VDD VDD) pmos w=2u l=100n
FSDPHQ_FFS_m_o_N0 (FSDPHQ_FFS_qm FSDPHQ_FFS_m_n2 VSS VSS) nmos w=1u l=100n
FSDPHQ_FFS_s_in_P (FSDPHQ_FFS_s_n1 FSDPHQ_FFS_ck_b FSDPHQ_FFS_qm VDD) pmos w=2u l=100n
FSDPHQ_FFS_s_in_N (FSDPHQ_FFS_s_n1 CK FSDPHQ_FFS_qm VSS) nmos w=1u l=100n
FSDPHQ_FFS_s_i1_P0 (FSDPHQ_FFS_s_n2 FSDPHQ_FFS_s_n1 VDD VDD) pmos w=2u l=100n
FSDPHQ_FFS_s_i1_N0 (FSDPHQ_FFS_s_n2 FSDPHQ_FFS_s_n1 VSS VSS) nmos w=1u l=100n
FSDPHQ_FFS_s_i2_P0 (FSDPHQ_FFS_s_n1 FSDPHQ_FFS_s_n2 VDD VDD) pmos w=2u l=100n
FSDPHQ_FFS_s_i2_N0 (FSDPHQ_FFS_s_n1 FSDPHQ_FFS_s_n2 VSS VSS) nmos w=1u l=100n
FSDPHQ_FFS_s_fb_P (FSDPHQ_FFS_s_n1 CK FSDPHQ_FFS_s_n2 VDD) pmos w=2u l=100n
FSDPHQ_FFS_s_fb_N (FSDPHQ_FFS_s_n1 FSDPHQ_FFS_ck_b FSDPHQ_FFS_s_n2 VSS) nmos w=1u l=100n
FSDPHQ_FFS_s_o_P0 (Q FSDPHQ_FFS_s_n2 VDD VDD) pmos w=2u l=100n
FSDPHQ_FFS_s_o_N0 (Q FSDPHQ_FFS_s_n2 VSS VSS) nmos w=1u l=100n
ends fsdphq_ffs_x1
