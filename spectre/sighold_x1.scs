subckt sighold_x1 SH VDD VSS
* Physical cell: abstract subckt (rails per PDK CDL; add PDK devices if needed).
ends sighold_x1
