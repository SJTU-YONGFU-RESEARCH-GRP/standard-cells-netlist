subckt mult4x4_x1 A0 A1 A2 A3 B0 B1 B2 B3 P0 P1 P2 P3 P4 P5 P6 P7 VDD VSS
M44_PP00_N_PA0 (m44_pp00_n A0 VDD VDD) pmos w=2u l=100n
M44_PP00_N_PB0 (m44_pp00_n B0 VDD VDD) pmos w=2u l=100n
M44_PP00_N_NB0 (m44_pp00_n B0 nmid_M44_PP00_N_0 VSS) nmos w=1u l=100n
M44_PP00_N_NA0 (nmid_M44_PP00_N_0 A0 VSS VSS) nmos w=1u l=100n
M44_PP00_I_P0 (m44_pp00 m44_pp00_n VDD VDD) pmos w=2u l=100n
M44_PP00_I_N0 (m44_pp00 m44_pp00_n VSS VSS) nmos w=1u l=100n
M44_PP01_N_PA0 (m44_pp01_n A0 VDD VDD) pmos w=2u l=100n
M44_PP01_N_PB0 (m44_pp01_n B1 VDD VDD) pmos w=2u l=100n
M44_PP01_N_NB0 (m44_pp01_n B1 nmid_M44_PP01_N_0 VSS) nmos w=1u l=100n
M44_PP01_N_NA0 (nmid_M44_PP01_N_0 A0 VSS VSS) nmos w=1u l=100n
M44_PP01_I_P0 (m44_pp01 m44_pp01_n VDD VDD) pmos w=2u l=100n
M44_PP01_I_N0 (m44_pp01 m44_pp01_n VSS VSS) nmos w=1u l=100n
M44_PP02_N_PA0 (m44_pp02_n A0 VDD VDD) pmos w=2u l=100n
M44_PP02_N_PB0 (m44_pp02_n B2 VDD VDD) pmos w=2u l=100n
M44_PP02_N_NB0 (m44_pp02_n B2 nmid_M44_PP02_N_0 VSS) nmos w=1u l=100n
M44_PP02_N_NA0 (nmid_M44_PP02_N_0 A0 VSS VSS) nmos w=1u l=100n
M44_PP02_I_P0 (m44_pp02 m44_pp02_n VDD VDD) pmos w=2u l=100n
M44_PP02_I_N0 (m44_pp02 m44_pp02_n VSS VSS) nmos w=1u l=100n
M44_PP03_N_PA0 (m44_pp03_n A0 VDD VDD) pmos w=2u l=100n
M44_PP03_N_PB0 (m44_pp03_n B3 VDD VDD) pmos w=2u l=100n
M44_PP03_N_NB0 (m44_pp03_n B3 nmid_M44_PP03_N_0 VSS) nmos w=1u l=100n
M44_PP03_N_NA0 (nmid_M44_PP03_N_0 A0 VSS VSS) nmos w=1u l=100n
M44_PP03_I_P0 (m44_pp03 m44_pp03_n VDD VDD) pmos w=2u l=100n
M44_PP03_I_N0 (m44_pp03 m44_pp03_n VSS VSS) nmos w=1u l=100n
M44_PP10_N_PA0 (m44_pp10_n A1 VDD VDD) pmos w=2u l=100n
M44_PP10_N_PB0 (m44_pp10_n B0 VDD VDD) pmos w=2u l=100n
M44_PP10_N_NB0 (m44_pp10_n B0 nmid_M44_PP10_N_0 VSS) nmos w=1u l=100n
M44_PP10_N_NA0 (nmid_M44_PP10_N_0 A1 VSS VSS) nmos w=1u l=100n
M44_PP10_I_P0 (m44_pp10 m44_pp10_n VDD VDD) pmos w=2u l=100n
M44_PP10_I_N0 (m44_pp10 m44_pp10_n VSS VSS) nmos w=1u l=100n
M44_PP11_N_PA0 (m44_pp11_n A1 VDD VDD) pmos w=2u l=100n
M44_PP11_N_PB0 (m44_pp11_n B1 VDD VDD) pmos w=2u l=100n
M44_PP11_N_NB0 (m44_pp11_n B1 nmid_M44_PP11_N_0 VSS) nmos w=1u l=100n
M44_PP11_N_NA0 (nmid_M44_PP11_N_0 A1 VSS VSS) nmos w=1u l=100n
M44_PP11_I_P0 (m44_pp11 m44_pp11_n VDD VDD) pmos w=2u l=100n
M44_PP11_I_N0 (m44_pp11 m44_pp11_n VSS VSS) nmos w=1u l=100n
M44_PP12_N_PA0 (m44_pp12_n A1 VDD VDD) pmos w=2u l=100n
M44_PP12_N_PB0 (m44_pp12_n B2 VDD VDD) pmos w=2u l=100n
M44_PP12_N_NB0 (m44_pp12_n B2 nmid_M44_PP12_N_0 VSS) nmos w=1u l=100n
M44_PP12_N_NA0 (nmid_M44_PP12_N_0 A1 VSS VSS) nmos w=1u l=100n
M44_PP12_I_P0 (m44_pp12 m44_pp12_n VDD VDD) pmos w=2u l=100n
M44_PP12_I_N0 (m44_pp12 m44_pp12_n VSS VSS) nmos w=1u l=100n
M44_PP13_N_PA0 (m44_pp13_n A1 VDD VDD) pmos w=2u l=100n
M44_PP13_N_PB0 (m44_pp13_n B3 VDD VDD) pmos w=2u l=100n
M44_PP13_N_NB0 (m44_pp13_n B3 nmid_M44_PP13_N_0 VSS) nmos w=1u l=100n
M44_PP13_N_NA0 (nmid_M44_PP13_N_0 A1 VSS VSS) nmos w=1u l=100n
M44_PP13_I_P0 (m44_pp13 m44_pp13_n VDD VDD) pmos w=2u l=100n
M44_PP13_I_N0 (m44_pp13 m44_pp13_n VSS VSS) nmos w=1u l=100n
M44_PP20_N_PA0 (m44_pp20_n A2 VDD VDD) pmos w=2u l=100n
M44_PP20_N_PB0 (m44_pp20_n B0 VDD VDD) pmos w=2u l=100n
M44_PP20_N_NB0 (m44_pp20_n B0 nmid_M44_PP20_N_0 VSS) nmos w=1u l=100n
M44_PP20_N_NA0 (nmid_M44_PP20_N_0 A2 VSS VSS) nmos w=1u l=100n
M44_PP20_I_P0 (m44_pp20 m44_pp20_n VDD VDD) pmos w=2u l=100n
M44_PP20_I_N0 (m44_pp20 m44_pp20_n VSS VSS) nmos w=1u l=100n
M44_PP21_N_PA0 (m44_pp21_n A2 VDD VDD) pmos w=2u l=100n
M44_PP21_N_PB0 (m44_pp21_n B1 VDD VDD) pmos w=2u l=100n
M44_PP21_N_NB0 (m44_pp21_n B1 nmid_M44_PP21_N_0 VSS) nmos w=1u l=100n
M44_PP21_N_NA0 (nmid_M44_PP21_N_0 A2 VSS VSS) nmos w=1u l=100n
M44_PP21_I_P0 (m44_pp21 m44_pp21_n VDD VDD) pmos w=2u l=100n
M44_PP21_I_N0 (m44_pp21 m44_pp21_n VSS VSS) nmos w=1u l=100n
M44_PP22_N_PA0 (m44_pp22_n A2 VDD VDD) pmos w=2u l=100n
M44_PP22_N_PB0 (m44_pp22_n B2 VDD VDD) pmos w=2u l=100n
M44_PP22_N_NB0 (m44_pp22_n B2 nmid_M44_PP22_N_0 VSS) nmos w=1u l=100n
M44_PP22_N_NA0 (nmid_M44_PP22_N_0 A2 VSS VSS) nmos w=1u l=100n
M44_PP22_I_P0 (m44_pp22 m44_pp22_n VDD VDD) pmos w=2u l=100n
M44_PP22_I_N0 (m44_pp22 m44_pp22_n VSS VSS) nmos w=1u l=100n
M44_PP23_N_PA0 (m44_pp23_n A2 VDD VDD) pmos w=2u l=100n
M44_PP23_N_PB0 (m44_pp23_n B3 VDD VDD) pmos w=2u l=100n
M44_PP23_N_NB0 (m44_pp23_n B3 nmid_M44_PP23_N_0 VSS) nmos w=1u l=100n
M44_PP23_N_NA0 (nmid_M44_PP23_N_0 A2 VSS VSS) nmos w=1u l=100n
M44_PP23_I_P0 (m44_pp23 m44_pp23_n VDD VDD) pmos w=2u l=100n
M44_PP23_I_N0 (m44_pp23 m44_pp23_n VSS VSS) nmos w=1u l=100n
M44_PP30_N_PA0 (m44_pp30_n A3 VDD VDD) pmos w=2u l=100n
M44_PP30_N_PB0 (m44_pp30_n B0 VDD VDD) pmos w=2u l=100n
M44_PP30_N_NB0 (m44_pp30_n B0 nmid_M44_PP30_N_0 VSS) nmos w=1u l=100n
M44_PP30_N_NA0 (nmid_M44_PP30_N_0 A3 VSS VSS) nmos w=1u l=100n
M44_PP30_I_P0 (m44_pp30 m44_pp30_n VDD VDD) pmos w=2u l=100n
M44_PP30_I_N0 (m44_pp30 m44_pp30_n VSS VSS) nmos w=1u l=100n
M44_PP31_N_PA0 (m44_pp31_n A3 VDD VDD) pmos w=2u l=100n
M44_PP31_N_PB0 (m44_pp31_n B1 VDD VDD) pmos w=2u l=100n
M44_PP31_N_NB0 (m44_pp31_n B1 nmid_M44_PP31_N_0 VSS) nmos w=1u l=100n
M44_PP31_N_NA0 (nmid_M44_PP31_N_0 A3 VSS VSS) nmos w=1u l=100n
M44_PP31_I_P0 (m44_pp31 m44_pp31_n VDD VDD) pmos w=2u l=100n
M44_PP31_I_N0 (m44_pp31 m44_pp31_n VSS VSS) nmos w=1u l=100n
M44_PP32_N_PA0 (m44_pp32_n A3 VDD VDD) pmos w=2u l=100n
M44_PP32_N_PB0 (m44_pp32_n B2 VDD VDD) pmos w=2u l=100n
M44_PP32_N_NB0 (m44_pp32_n B2 nmid_M44_PP32_N_0 VSS) nmos w=1u l=100n
M44_PP32_N_NA0 (nmid_M44_PP32_N_0 A3 VSS VSS) nmos w=1u l=100n
M44_PP32_I_P0 (m44_pp32 m44_pp32_n VDD VDD) pmos w=2u l=100n
M44_PP32_I_N0 (m44_pp32 m44_pp32_n VSS VSS) nmos w=1u l=100n
M44_PP33_N_PA0 (m44_pp33_n A3 VDD VDD) pmos w=2u l=100n
M44_PP33_N_PB0 (m44_pp33_n B3 VDD VDD) pmos w=2u l=100n
M44_PP33_N_NB0 (m44_pp33_n B3 nmid_M44_PP33_N_0 VSS) nmos w=1u l=100n
M44_PP33_N_NA0 (nmid_M44_PP33_N_0 A3 VSS VSS) nmos w=1u l=100n
M44_PP33_I_P0 (m44_pp33 m44_pp33_n VDD VDD) pmos w=2u l=100n
M44_PP33_I_N0 (m44_pp33 m44_pp33_n VSS VSS) nmos w=1u l=100n
M44_S10_nr_PA0 (pmid_M44_S10_nr_0 m44_pp00 VDD VDD) pmos w=2u l=100n
M44_S10_nr_PB0 (x_nor_m44s10 VSS pmid_M44_S10_nr_0 VDD) pmos w=2u l=100n
M44_S10_nr_NA0 (x_nor_m44s10 m44_pp00 VSS VSS) nmos w=1u l=100n
M44_S10_nr_NB0 (x_nor_m44s10 VSS VSS VSS) nmos w=1u l=100n
M44_S10_iv_P0 (x_or_m44s10 x_nor_m44s10 VDD VDD) pmos w=2u l=100n
M44_S10_iv_N0 (x_or_m44s10 x_nor_m44s10 VSS VSS) nmos w=1u l=100n
M44_S10_nd_PA0 (x_nand_m44s10 m44_pp00 VDD VDD) pmos w=2u l=100n
M44_S10_nd_PB0 (x_nand_m44s10 VSS VDD VDD) pmos w=2u l=100n
M44_S10_nd_NB0 (x_nand_m44s10 VSS nmid_M44_S10_nd_0 VSS) nmos w=1u l=100n
M44_S10_nd_NA0 (nmid_M44_S10_nd_0 m44_pp00 VSS VSS) nmos w=1u l=100n
M44_S10_na_PA0 (x_pre_m44s10 x_or_m44s10 VDD VDD) pmos w=2u l=100n
M44_S10_na_PB0 (x_pre_m44s10 x_nand_m44s10 VDD VDD) pmos w=2u l=100n
M44_S10_na_NB0 (x_pre_m44s10 x_nand_m44s10 nmid_M44_S10_na_0 VSS) nmos w=1u l=100n
M44_S10_na_NA0 (nmid_M44_S10_na_0 x_or_m44s10 VSS VSS) nmos w=1u l=100n
M44_S10_xo_P0 (m44_s1_0 x_pre_m44s10 VDD VDD) pmos w=2u l=100n
M44_S10_xo_N0 (m44_s1_0 x_pre_m44s10 VSS VSS) nmos w=1u l=100n
M44_C11_N_PA0 (m44_c1_1_n m44_pp00 VDD VDD) pmos w=2u l=100n
M44_C11_N_PB0 (m44_c1_1_n VSS VDD VDD) pmos w=2u l=100n
M44_C11_N_NB0 (m44_c1_1_n VSS nmid_M44_C11_N_0 VSS) nmos w=1u l=100n
M44_C11_N_NA0 (nmid_M44_C11_N_0 m44_pp00 VSS VSS) nmos w=1u l=100n
M44_C11_I_P0 (m44_c1_1 m44_c1_1_n VDD VDD) pmos w=2u l=100n
M44_C11_I_N0 (m44_c1_1 m44_c1_1_n VSS VSS) nmos w=1u l=100n
M44_S1_1_X1_nr_PA0 (pmid_M44_S1_1_X1_nr_0 m44_pp10 VDD VDD) pmos w=2u l=100n
M44_S1_1_X1_nr_PB0 (x_nor_M44_S1_1_x1 m44_pp01 pmid_M44_S1_1_X1_nr_0 VDD) pmos w=2u l=100n
M44_S1_1_X1_nr_NA0 (x_nor_M44_S1_1_x1 m44_pp10 VSS VSS) nmos w=1u l=100n
M44_S1_1_X1_nr_NB0 (x_nor_M44_S1_1_x1 m44_pp01 VSS VSS) nmos w=1u l=100n
M44_S1_1_X1_iv_P0 (x_or_M44_S1_1_x1 x_nor_M44_S1_1_x1 VDD VDD) pmos w=2u l=100n
M44_S1_1_X1_iv_N0 (x_or_M44_S1_1_x1 x_nor_M44_S1_1_x1 VSS VSS) nmos w=1u l=100n
M44_S1_1_X1_nd_PA0 (x_nand_M44_S1_1_x1 m44_pp10 VDD VDD) pmos w=2u l=100n
M44_S1_1_X1_nd_PB0 (x_nand_M44_S1_1_x1 m44_pp01 VDD VDD) pmos w=2u l=100n
M44_S1_1_X1_nd_NB0 (x_nand_M44_S1_1_x1 m44_pp01 nmid_M44_S1_1_X1_nd_0 VSS) nmos w=1u l=100n
M44_S1_1_X1_nd_NA0 (nmid_M44_S1_1_X1_nd_0 m44_pp10 VSS VSS) nmos w=1u l=100n
M44_S1_1_X1_na_PA0 (x_pre_M44_S1_1_x1 x_or_M44_S1_1_x1 VDD VDD) pmos w=2u l=100n
M44_S1_1_X1_na_PB0 (x_pre_M44_S1_1_x1 x_nand_M44_S1_1_x1 VDD VDD) pmos w=2u l=100n
M44_S1_1_X1_na_NB0 (x_pre_M44_S1_1_x1 x_nand_M44_S1_1_x1 nmid_M44_S1_1_X1_na_0 VSS) nmos w=1u l=100n
M44_S1_1_X1_na_NA0 (nmid_M44_S1_1_X1_na_0 x_or_M44_S1_1_x1 VSS VSS) nmos w=1u l=100n
M44_S1_1_X1_xo_P0 (M44_S1_1_xab x_pre_M44_S1_1_x1 VDD VDD) pmos w=2u l=100n
M44_S1_1_X1_xo_N0 (M44_S1_1_xab x_pre_M44_S1_1_x1 VSS VSS) nmos w=1u l=100n
M44_S1_1_X2_nr_PA0 (pmid_M44_S1_1_X2_nr_0 M44_S1_1_xab VDD VDD) pmos w=2u l=100n
M44_S1_1_X2_nr_PB0 (x_nor_M44_S1_1_x2 m44_c1_1 pmid_M44_S1_1_X2_nr_0 VDD) pmos w=2u l=100n
M44_S1_1_X2_nr_NA0 (x_nor_M44_S1_1_x2 M44_S1_1_xab VSS VSS) nmos w=1u l=100n
M44_S1_1_X2_nr_NB0 (x_nor_M44_S1_1_x2 m44_c1_1 VSS VSS) nmos w=1u l=100n
M44_S1_1_X2_iv_P0 (x_or_M44_S1_1_x2 x_nor_M44_S1_1_x2 VDD VDD) pmos w=2u l=100n
M44_S1_1_X2_iv_N0 (x_or_M44_S1_1_x2 x_nor_M44_S1_1_x2 VSS VSS) nmos w=1u l=100n
M44_S1_1_X2_nd_PA0 (x_nand_M44_S1_1_x2 M44_S1_1_xab VDD VDD) pmos w=2u l=100n
M44_S1_1_X2_nd_PB0 (x_nand_M44_S1_1_x2 m44_c1_1 VDD VDD) pmos w=2u l=100n
M44_S1_1_X2_nd_NB0 (x_nand_M44_S1_1_x2 m44_c1_1 nmid_M44_S1_1_X2_nd_0 VSS) nmos w=1u l=100n
M44_S1_1_X2_nd_NA0 (nmid_M44_S1_1_X2_nd_0 M44_S1_1_xab VSS VSS) nmos w=1u l=100n
M44_S1_1_X2_na_PA0 (x_pre_M44_S1_1_x2 x_or_M44_S1_1_x2 VDD VDD) pmos w=2u l=100n
M44_S1_1_X2_na_PB0 (x_pre_M44_S1_1_x2 x_nand_M44_S1_1_x2 VDD VDD) pmos w=2u l=100n
M44_S1_1_X2_na_NB0 (x_pre_M44_S1_1_x2 x_nand_M44_S1_1_x2 nmid_M44_S1_1_X2_na_0 VSS) nmos w=1u l=100n
M44_S1_1_X2_na_NA0 (nmid_M44_S1_1_X2_na_0 x_or_M44_S1_1_x2 VSS VSS) nmos w=1u l=100n
M44_S1_1_X2_xo_P0 (m44_s1_1 x_pre_M44_S1_1_x2 VDD VDD) pmos w=2u l=100n
M44_S1_1_X2_xo_N0 (m44_s1_1 x_pre_M44_S1_1_x2 VSS VSS) nmos w=1u l=100n
M44_S1_1_AB_N_PA0 (M44_S1_1_ab_n m44_pp10 VDD VDD) pmos w=2u l=100n
M44_S1_1_AB_N_PB0 (M44_S1_1_ab_n m44_pp01 VDD VDD) pmos w=2u l=100n
M44_S1_1_AB_N_NB0 (M44_S1_1_ab_n m44_pp01 nmid_M44_S1_1_AB_N_0 VSS) nmos w=1u l=100n
M44_S1_1_AB_N_NA0 (nmid_M44_S1_1_AB_N_0 m44_pp10 VSS VSS) nmos w=1u l=100n
M44_S1_1_AB_I_P0 (M44_S1_1_ab M44_S1_1_ab_n VDD VDD) pmos w=2u l=100n
M44_S1_1_AB_I_N0 (M44_S1_1_ab M44_S1_1_ab_n VSS VSS) nmos w=1u l=100n
M44_S1_1_XC_N_PA0 (M44_S1_1_xc_n M44_S1_1_xab VDD VDD) pmos w=2u l=100n
M44_S1_1_XC_N_PB0 (M44_S1_1_xc_n m44_c1_1 VDD VDD) pmos w=2u l=100n
M44_S1_1_XC_N_NB0 (M44_S1_1_xc_n m44_c1_1 nmid_M44_S1_1_XC_N_0 VSS) nmos w=1u l=100n
M44_S1_1_XC_N_NA0 (nmid_M44_S1_1_XC_N_0 M44_S1_1_xab VSS VSS) nmos w=1u l=100n
M44_S1_1_XC_I_P0 (M44_S1_1_xc M44_S1_1_xc_n VDD VDD) pmos w=2u l=100n
M44_S1_1_XC_I_N0 (M44_S1_1_xc M44_S1_1_xc_n VSS VSS) nmos w=1u l=100n
M44_S1_1_OR_N_PA0 (pmid_M44_S1_1_OR_N_0 M44_S1_1_ab VDD VDD) pmos w=2u l=100n
M44_S1_1_OR_N_PB0 (m44_c1_2_n M44_S1_1_xc pmid_M44_S1_1_OR_N_0 VDD) pmos w=2u l=100n
M44_S1_1_OR_N_NA0 (m44_c1_2_n M44_S1_1_ab VSS VSS) nmos w=1u l=100n
M44_S1_1_OR_N_NB0 (m44_c1_2_n M44_S1_1_xc VSS VSS) nmos w=1u l=100n
M44_S1_1_OR_I_P0 (m44_c1_2 m44_c1_2_n VDD VDD) pmos w=2u l=100n
M44_S1_1_OR_I_N0 (m44_c1_2 m44_c1_2_n VSS VSS) nmos w=1u l=100n
M44_S1_2_X1_nr_PA0 (pmid_M44_S1_2_X1_nr_0 m44_pp20 VDD VDD) pmos w=2u l=100n
M44_S1_2_X1_nr_PB0 (x_nor_M44_S1_2_x1 m44_pp11 pmid_M44_S1_2_X1_nr_0 VDD) pmos w=2u l=100n
M44_S1_2_X1_nr_NA0 (x_nor_M44_S1_2_x1 m44_pp20 VSS VSS) nmos w=1u l=100n
M44_S1_2_X1_nr_NB0 (x_nor_M44_S1_2_x1 m44_pp11 VSS VSS) nmos w=1u l=100n
M44_S1_2_X1_iv_P0 (x_or_M44_S1_2_x1 x_nor_M44_S1_2_x1 VDD VDD) pmos w=2u l=100n
M44_S1_2_X1_iv_N0 (x_or_M44_S1_2_x1 x_nor_M44_S1_2_x1 VSS VSS) nmos w=1u l=100n
M44_S1_2_X1_nd_PA0 (x_nand_M44_S1_2_x1 m44_pp20 VDD VDD) pmos w=2u l=100n
M44_S1_2_X1_nd_PB0 (x_nand_M44_S1_2_x1 m44_pp11 VDD VDD) pmos w=2u l=100n
M44_S1_2_X1_nd_NB0 (x_nand_M44_S1_2_x1 m44_pp11 nmid_M44_S1_2_X1_nd_0 VSS) nmos w=1u l=100n
M44_S1_2_X1_nd_NA0 (nmid_M44_S1_2_X1_nd_0 m44_pp20 VSS VSS) nmos w=1u l=100n
M44_S1_2_X1_na_PA0 (x_pre_M44_S1_2_x1 x_or_M44_S1_2_x1 VDD VDD) pmos w=2u l=100n
M44_S1_2_X1_na_PB0 (x_pre_M44_S1_2_x1 x_nand_M44_S1_2_x1 VDD VDD) pmos w=2u l=100n
M44_S1_2_X1_na_NB0 (x_pre_M44_S1_2_x1 x_nand_M44_S1_2_x1 nmid_M44_S1_2_X1_na_0 VSS) nmos w=1u l=100n
M44_S1_2_X1_na_NA0 (nmid_M44_S1_2_X1_na_0 x_or_M44_S1_2_x1 VSS VSS) nmos w=1u l=100n
M44_S1_2_X1_xo_P0 (M44_S1_2_xab x_pre_M44_S1_2_x1 VDD VDD) pmos w=2u l=100n
M44_S1_2_X1_xo_N0 (M44_S1_2_xab x_pre_M44_S1_2_x1 VSS VSS) nmos w=1u l=100n
M44_S1_2_X2_nr_PA0 (pmid_M44_S1_2_X2_nr_0 M44_S1_2_xab VDD VDD) pmos w=2u l=100n
M44_S1_2_X2_nr_PB0 (x_nor_M44_S1_2_x2 m44_c1_2 pmid_M44_S1_2_X2_nr_0 VDD) pmos w=2u l=100n
M44_S1_2_X2_nr_NA0 (x_nor_M44_S1_2_x2 M44_S1_2_xab VSS VSS) nmos w=1u l=100n
M44_S1_2_X2_nr_NB0 (x_nor_M44_S1_2_x2 m44_c1_2 VSS VSS) nmos w=1u l=100n
M44_S1_2_X2_iv_P0 (x_or_M44_S1_2_x2 x_nor_M44_S1_2_x2 VDD VDD) pmos w=2u l=100n
M44_S1_2_X2_iv_N0 (x_or_M44_S1_2_x2 x_nor_M44_S1_2_x2 VSS VSS) nmos w=1u l=100n
M44_S1_2_X2_nd_PA0 (x_nand_M44_S1_2_x2 M44_S1_2_xab VDD VDD) pmos w=2u l=100n
M44_S1_2_X2_nd_PB0 (x_nand_M44_S1_2_x2 m44_c1_2 VDD VDD) pmos w=2u l=100n
M44_S1_2_X2_nd_NB0 (x_nand_M44_S1_2_x2 m44_c1_2 nmid_M44_S1_2_X2_nd_0 VSS) nmos w=1u l=100n
M44_S1_2_X2_nd_NA0 (nmid_M44_S1_2_X2_nd_0 M44_S1_2_xab VSS VSS) nmos w=1u l=100n
M44_S1_2_X2_na_PA0 (x_pre_M44_S1_2_x2 x_or_M44_S1_2_x2 VDD VDD) pmos w=2u l=100n
M44_S1_2_X2_na_PB0 (x_pre_M44_S1_2_x2 x_nand_M44_S1_2_x2 VDD VDD) pmos w=2u l=100n
M44_S1_2_X2_na_NB0 (x_pre_M44_S1_2_x2 x_nand_M44_S1_2_x2 nmid_M44_S1_2_X2_na_0 VSS) nmos w=1u l=100n
M44_S1_2_X2_na_NA0 (nmid_M44_S1_2_X2_na_0 x_or_M44_S1_2_x2 VSS VSS) nmos w=1u l=100n
M44_S1_2_X2_xo_P0 (m44_s1_2 x_pre_M44_S1_2_x2 VDD VDD) pmos w=2u l=100n
M44_S1_2_X2_xo_N0 (m44_s1_2 x_pre_M44_S1_2_x2 VSS VSS) nmos w=1u l=100n
M44_S1_2_AB_N_PA0 (M44_S1_2_ab_n m44_pp20 VDD VDD) pmos w=2u l=100n
M44_S1_2_AB_N_PB0 (M44_S1_2_ab_n m44_pp11 VDD VDD) pmos w=2u l=100n
M44_S1_2_AB_N_NB0 (M44_S1_2_ab_n m44_pp11 nmid_M44_S1_2_AB_N_0 VSS) nmos w=1u l=100n
M44_S1_2_AB_N_NA0 (nmid_M44_S1_2_AB_N_0 m44_pp20 VSS VSS) nmos w=1u l=100n
M44_S1_2_AB_I_P0 (M44_S1_2_ab M44_S1_2_ab_n VDD VDD) pmos w=2u l=100n
M44_S1_2_AB_I_N0 (M44_S1_2_ab M44_S1_2_ab_n VSS VSS) nmos w=1u l=100n
M44_S1_2_XC_N_PA0 (M44_S1_2_xc_n M44_S1_2_xab VDD VDD) pmos w=2u l=100n
M44_S1_2_XC_N_PB0 (M44_S1_2_xc_n m44_c1_2 VDD VDD) pmos w=2u l=100n
M44_S1_2_XC_N_NB0 (M44_S1_2_xc_n m44_c1_2 nmid_M44_S1_2_XC_N_0 VSS) nmos w=1u l=100n
M44_S1_2_XC_N_NA0 (nmid_M44_S1_2_XC_N_0 M44_S1_2_xab VSS VSS) nmos w=1u l=100n
M44_S1_2_XC_I_P0 (M44_S1_2_xc M44_S1_2_xc_n VDD VDD) pmos w=2u l=100n
M44_S1_2_XC_I_N0 (M44_S1_2_xc M44_S1_2_xc_n VSS VSS) nmos w=1u l=100n
M44_S1_2_OR_N_PA0 (pmid_M44_S1_2_OR_N_0 M44_S1_2_ab VDD VDD) pmos w=2u l=100n
M44_S1_2_OR_N_PB0 (m44_c1_3_n M44_S1_2_xc pmid_M44_S1_2_OR_N_0 VDD) pmos w=2u l=100n
M44_S1_2_OR_N_NA0 (m44_c1_3_n M44_S1_2_ab VSS VSS) nmos w=1u l=100n
M44_S1_2_OR_N_NB0 (m44_c1_3_n M44_S1_2_xc VSS VSS) nmos w=1u l=100n
M44_S1_2_OR_I_P0 (m44_c1_3 m44_c1_3_n VDD VDD) pmos w=2u l=100n
M44_S1_2_OR_I_N0 (m44_c1_3 m44_c1_3_n VSS VSS) nmos w=1u l=100n
M44_S1_3_X1_nr_PA0 (pmid_M44_S1_3_X1_nr_0 m44_pp30 VDD VDD) pmos w=2u l=100n
M44_S1_3_X1_nr_PB0 (x_nor_M44_S1_3_x1 m44_pp21 pmid_M44_S1_3_X1_nr_0 VDD) pmos w=2u l=100n
M44_S1_3_X1_nr_NA0 (x_nor_M44_S1_3_x1 m44_pp30 VSS VSS) nmos w=1u l=100n
M44_S1_3_X1_nr_NB0 (x_nor_M44_S1_3_x1 m44_pp21 VSS VSS) nmos w=1u l=100n
M44_S1_3_X1_iv_P0 (x_or_M44_S1_3_x1 x_nor_M44_S1_3_x1 VDD VDD) pmos w=2u l=100n
M44_S1_3_X1_iv_N0 (x_or_M44_S1_3_x1 x_nor_M44_S1_3_x1 VSS VSS) nmos w=1u l=100n
M44_S1_3_X1_nd_PA0 (x_nand_M44_S1_3_x1 m44_pp30 VDD VDD) pmos w=2u l=100n
M44_S1_3_X1_nd_PB0 (x_nand_M44_S1_3_x1 m44_pp21 VDD VDD) pmos w=2u l=100n
M44_S1_3_X1_nd_NB0 (x_nand_M44_S1_3_x1 m44_pp21 nmid_M44_S1_3_X1_nd_0 VSS) nmos w=1u l=100n
M44_S1_3_X1_nd_NA0 (nmid_M44_S1_3_X1_nd_0 m44_pp30 VSS VSS) nmos w=1u l=100n
M44_S1_3_X1_na_PA0 (x_pre_M44_S1_3_x1 x_or_M44_S1_3_x1 VDD VDD) pmos w=2u l=100n
M44_S1_3_X1_na_PB0 (x_pre_M44_S1_3_x1 x_nand_M44_S1_3_x1 VDD VDD) pmos w=2u l=100n
M44_S1_3_X1_na_NB0 (x_pre_M44_S1_3_x1 x_nand_M44_S1_3_x1 nmid_M44_S1_3_X1_na_0 VSS) nmos w=1u l=100n
M44_S1_3_X1_na_NA0 (nmid_M44_S1_3_X1_na_0 x_or_M44_S1_3_x1 VSS VSS) nmos w=1u l=100n
M44_S1_3_X1_xo_P0 (M44_S1_3_xab x_pre_M44_S1_3_x1 VDD VDD) pmos w=2u l=100n
M44_S1_3_X1_xo_N0 (M44_S1_3_xab x_pre_M44_S1_3_x1 VSS VSS) nmos w=1u l=100n
M44_S1_3_X2_nr_PA0 (pmid_M44_S1_3_X2_nr_0 M44_S1_3_xab VDD VDD) pmos w=2u l=100n
M44_S1_3_X2_nr_PB0 (x_nor_M44_S1_3_x2 m44_c1_3 pmid_M44_S1_3_X2_nr_0 VDD) pmos w=2u l=100n
M44_S1_3_X2_nr_NA0 (x_nor_M44_S1_3_x2 M44_S1_3_xab VSS VSS) nmos w=1u l=100n
M44_S1_3_X2_nr_NB0 (x_nor_M44_S1_3_x2 m44_c1_3 VSS VSS) nmos w=1u l=100n
M44_S1_3_X2_iv_P0 (x_or_M44_S1_3_x2 x_nor_M44_S1_3_x2 VDD VDD) pmos w=2u l=100n
M44_S1_3_X2_iv_N0 (x_or_M44_S1_3_x2 x_nor_M44_S1_3_x2 VSS VSS) nmos w=1u l=100n
M44_S1_3_X2_nd_PA0 (x_nand_M44_S1_3_x2 M44_S1_3_xab VDD VDD) pmos w=2u l=100n
M44_S1_3_X2_nd_PB0 (x_nand_M44_S1_3_x2 m44_c1_3 VDD VDD) pmos w=2u l=100n
M44_S1_3_X2_nd_NB0 (x_nand_M44_S1_3_x2 m44_c1_3 nmid_M44_S1_3_X2_nd_0 VSS) nmos w=1u l=100n
M44_S1_3_X2_nd_NA0 (nmid_M44_S1_3_X2_nd_0 M44_S1_3_xab VSS VSS) nmos w=1u l=100n
M44_S1_3_X2_na_PA0 (x_pre_M44_S1_3_x2 x_or_M44_S1_3_x2 VDD VDD) pmos w=2u l=100n
M44_S1_3_X2_na_PB0 (x_pre_M44_S1_3_x2 x_nand_M44_S1_3_x2 VDD VDD) pmos w=2u l=100n
M44_S1_3_X2_na_NB0 (x_pre_M44_S1_3_x2 x_nand_M44_S1_3_x2 nmid_M44_S1_3_X2_na_0 VSS) nmos w=1u l=100n
M44_S1_3_X2_na_NA0 (nmid_M44_S1_3_X2_na_0 x_or_M44_S1_3_x2 VSS VSS) nmos w=1u l=100n
M44_S1_3_X2_xo_P0 (m44_s1_3 x_pre_M44_S1_3_x2 VDD VDD) pmos w=2u l=100n
M44_S1_3_X2_xo_N0 (m44_s1_3 x_pre_M44_S1_3_x2 VSS VSS) nmos w=1u l=100n
M44_S1_3_AB_N_PA0 (M44_S1_3_ab_n m44_pp30 VDD VDD) pmos w=2u l=100n
M44_S1_3_AB_N_PB0 (M44_S1_3_ab_n m44_pp21 VDD VDD) pmos w=2u l=100n
M44_S1_3_AB_N_NB0 (M44_S1_3_ab_n m44_pp21 nmid_M44_S1_3_AB_N_0 VSS) nmos w=1u l=100n
M44_S1_3_AB_N_NA0 (nmid_M44_S1_3_AB_N_0 m44_pp30 VSS VSS) nmos w=1u l=100n
M44_S1_3_AB_I_P0 (M44_S1_3_ab M44_S1_3_ab_n VDD VDD) pmos w=2u l=100n
M44_S1_3_AB_I_N0 (M44_S1_3_ab M44_S1_3_ab_n VSS VSS) nmos w=1u l=100n
M44_S1_3_XC_N_PA0 (M44_S1_3_xc_n M44_S1_3_xab VDD VDD) pmos w=2u l=100n
M44_S1_3_XC_N_PB0 (M44_S1_3_xc_n m44_c1_3 VDD VDD) pmos w=2u l=100n
M44_S1_3_XC_N_NB0 (M44_S1_3_xc_n m44_c1_3 nmid_M44_S1_3_XC_N_0 VSS) nmos w=1u l=100n
M44_S1_3_XC_N_NA0 (nmid_M44_S1_3_XC_N_0 M44_S1_3_xab VSS VSS) nmos w=1u l=100n
M44_S1_3_XC_I_P0 (M44_S1_3_xc M44_S1_3_xc_n VDD VDD) pmos w=2u l=100n
M44_S1_3_XC_I_N0 (M44_S1_3_xc M44_S1_3_xc_n VSS VSS) nmos w=1u l=100n
M44_S1_3_OR_N_PA0 (pmid_M44_S1_3_OR_N_0 M44_S1_3_ab VDD VDD) pmos w=2u l=100n
M44_S1_3_OR_N_PB0 (m44_c1_4_n M44_S1_3_xc pmid_M44_S1_3_OR_N_0 VDD) pmos w=2u l=100n
M44_S1_3_OR_N_NA0 (m44_c1_4_n M44_S1_3_ab VSS VSS) nmos w=1u l=100n
M44_S1_3_OR_N_NB0 (m44_c1_4_n M44_S1_3_xc VSS VSS) nmos w=1u l=100n
M44_S1_3_OR_I_P0 (m44_c1_4 m44_c1_4_n VDD VDD) pmos w=2u l=100n
M44_S1_3_OR_I_N0 (m44_c1_4 m44_c1_4_n VSS VSS) nmos w=1u l=100n
M44_S1_4_X1_nr_PA0 (pmid_M44_S1_4_X1_nr_0 VSS VDD VDD) pmos w=2u l=100n
M44_S1_4_X1_nr_PB0 (x_nor_M44_S1_4_x1 m44_pp31 pmid_M44_S1_4_X1_nr_0 VDD) pmos w=2u l=100n
M44_S1_4_X1_nr_NA0 (x_nor_M44_S1_4_x1 VSS VSS VSS) nmos w=1u l=100n
M44_S1_4_X1_nr_NB0 (x_nor_M44_S1_4_x1 m44_pp31 VSS VSS) nmos w=1u l=100n
M44_S1_4_X1_iv_P0 (x_or_M44_S1_4_x1 x_nor_M44_S1_4_x1 VDD VDD) pmos w=2u l=100n
M44_S1_4_X1_iv_N0 (x_or_M44_S1_4_x1 x_nor_M44_S1_4_x1 VSS VSS) nmos w=1u l=100n
M44_S1_4_X1_nd_PA0 (x_nand_M44_S1_4_x1 VSS VDD VDD) pmos w=2u l=100n
M44_S1_4_X1_nd_PB0 (x_nand_M44_S1_4_x1 m44_pp31 VDD VDD) pmos w=2u l=100n
M44_S1_4_X1_nd_NB0 (x_nand_M44_S1_4_x1 m44_pp31 nmid_M44_S1_4_X1_nd_0 VSS) nmos w=1u l=100n
M44_S1_4_X1_nd_NA0 (nmid_M44_S1_4_X1_nd_0 VSS VSS VSS) nmos w=1u l=100n
M44_S1_4_X1_na_PA0 (x_pre_M44_S1_4_x1 x_or_M44_S1_4_x1 VDD VDD) pmos w=2u l=100n
M44_S1_4_X1_na_PB0 (x_pre_M44_S1_4_x1 x_nand_M44_S1_4_x1 VDD VDD) pmos w=2u l=100n
M44_S1_4_X1_na_NB0 (x_pre_M44_S1_4_x1 x_nand_M44_S1_4_x1 nmid_M44_S1_4_X1_na_0 VSS) nmos w=1u l=100n
M44_S1_4_X1_na_NA0 (nmid_M44_S1_4_X1_na_0 x_or_M44_S1_4_x1 VSS VSS) nmos w=1u l=100n
M44_S1_4_X1_xo_P0 (M44_S1_4_xab x_pre_M44_S1_4_x1 VDD VDD) pmos w=2u l=100n
M44_S1_4_X1_xo_N0 (M44_S1_4_xab x_pre_M44_S1_4_x1 VSS VSS) nmos w=1u l=100n
M44_S1_4_X2_nr_PA0 (pmid_M44_S1_4_X2_nr_0 M44_S1_4_xab VDD VDD) pmos w=2u l=100n
M44_S1_4_X2_nr_PB0 (x_nor_M44_S1_4_x2 m44_c1_4 pmid_M44_S1_4_X2_nr_0 VDD) pmos w=2u l=100n
M44_S1_4_X2_nr_NA0 (x_nor_M44_S1_4_x2 M44_S1_4_xab VSS VSS) nmos w=1u l=100n
M44_S1_4_X2_nr_NB0 (x_nor_M44_S1_4_x2 m44_c1_4 VSS VSS) nmos w=1u l=100n
M44_S1_4_X2_iv_P0 (x_or_M44_S1_4_x2 x_nor_M44_S1_4_x2 VDD VDD) pmos w=2u l=100n
M44_S1_4_X2_iv_N0 (x_or_M44_S1_4_x2 x_nor_M44_S1_4_x2 VSS VSS) nmos w=1u l=100n
M44_S1_4_X2_nd_PA0 (x_nand_M44_S1_4_x2 M44_S1_4_xab VDD VDD) pmos w=2u l=100n
M44_S1_4_X2_nd_PB0 (x_nand_M44_S1_4_x2 m44_c1_4 VDD VDD) pmos w=2u l=100n
M44_S1_4_X2_nd_NB0 (x_nand_M44_S1_4_x2 m44_c1_4 nmid_M44_S1_4_X2_nd_0 VSS) nmos w=1u l=100n
M44_S1_4_X2_nd_NA0 (nmid_M44_S1_4_X2_nd_0 M44_S1_4_xab VSS VSS) nmos w=1u l=100n
M44_S1_4_X2_na_PA0 (x_pre_M44_S1_4_x2 x_or_M44_S1_4_x2 VDD VDD) pmos w=2u l=100n
M44_S1_4_X2_na_PB0 (x_pre_M44_S1_4_x2 x_nand_M44_S1_4_x2 VDD VDD) pmos w=2u l=100n
M44_S1_4_X2_na_NB0 (x_pre_M44_S1_4_x2 x_nand_M44_S1_4_x2 nmid_M44_S1_4_X2_na_0 VSS) nmos w=1u l=100n
M44_S1_4_X2_na_NA0 (nmid_M44_S1_4_X2_na_0 x_or_M44_S1_4_x2 VSS VSS) nmos w=1u l=100n
M44_S1_4_X2_xo_P0 (m44_s1_4 x_pre_M44_S1_4_x2 VDD VDD) pmos w=2u l=100n
M44_S1_4_X2_xo_N0 (m44_s1_4 x_pre_M44_S1_4_x2 VSS VSS) nmos w=1u l=100n
M44_S1_4_AB_N_PA0 (M44_S1_4_ab_n VSS VDD VDD) pmos w=2u l=100n
M44_S1_4_AB_N_PB0 (M44_S1_4_ab_n m44_pp31 VDD VDD) pmos w=2u l=100n
M44_S1_4_AB_N_NB0 (M44_S1_4_ab_n m44_pp31 nmid_M44_S1_4_AB_N_0 VSS) nmos w=1u l=100n
M44_S1_4_AB_N_NA0 (nmid_M44_S1_4_AB_N_0 VSS VSS VSS) nmos w=1u l=100n
M44_S1_4_AB_I_P0 (M44_S1_4_ab M44_S1_4_ab_n VDD VDD) pmos w=2u l=100n
M44_S1_4_AB_I_N0 (M44_S1_4_ab M44_S1_4_ab_n VSS VSS) nmos w=1u l=100n
M44_S1_4_XC_N_PA0 (M44_S1_4_xc_n M44_S1_4_xab VDD VDD) pmos w=2u l=100n
M44_S1_4_XC_N_PB0 (M44_S1_4_xc_n m44_c1_4 VDD VDD) pmos w=2u l=100n
M44_S1_4_XC_N_NB0 (M44_S1_4_xc_n m44_c1_4 nmid_M44_S1_4_XC_N_0 VSS) nmos w=1u l=100n
M44_S1_4_XC_N_NA0 (nmid_M44_S1_4_XC_N_0 M44_S1_4_xab VSS VSS) nmos w=1u l=100n
M44_S1_4_XC_I_P0 (M44_S1_4_xc M44_S1_4_xc_n VDD VDD) pmos w=2u l=100n
M44_S1_4_XC_I_N0 (M44_S1_4_xc M44_S1_4_xc_n VSS VSS) nmos w=1u l=100n
M44_S1_4_OR_N_PA0 (pmid_M44_S1_4_OR_N_0 M44_S1_4_ab VDD VDD) pmos w=2u l=100n
M44_S1_4_OR_N_PB0 (m44_c1_5_n M44_S1_4_xc pmid_M44_S1_4_OR_N_0 VDD) pmos w=2u l=100n
M44_S1_4_OR_N_NA0 (m44_c1_5_n M44_S1_4_ab VSS VSS) nmos w=1u l=100n
M44_S1_4_OR_N_NB0 (m44_c1_5_n M44_S1_4_xc VSS VSS) nmos w=1u l=100n
M44_S1_4_OR_I_P0 (m44_c1_5 m44_c1_5_n VDD VDD) pmos w=2u l=100n
M44_S1_4_OR_I_N0 (m44_c1_5 m44_c1_5_n VSS VSS) nmos w=1u l=100n
M44_S1_5_X1_nr_PA0 (pmid_M44_S1_5_X1_nr_0 VSS VDD VDD) pmos w=2u l=100n
M44_S1_5_X1_nr_PB0 (x_nor_M44_S1_5_x1 VSS pmid_M44_S1_5_X1_nr_0 VDD) pmos w=2u l=100n
M44_S1_5_X1_nr_NA0 (x_nor_M44_S1_5_x1 VSS VSS VSS) nmos w=1u l=100n
M44_S1_5_X1_nr_NB0 (x_nor_M44_S1_5_x1 VSS VSS VSS) nmos w=1u l=100n
M44_S1_5_X1_iv_P0 (x_or_M44_S1_5_x1 x_nor_M44_S1_5_x1 VDD VDD) pmos w=2u l=100n
M44_S1_5_X1_iv_N0 (x_or_M44_S1_5_x1 x_nor_M44_S1_5_x1 VSS VSS) nmos w=1u l=100n
M44_S1_5_X1_nd_PA0 (x_nand_M44_S1_5_x1 VSS VDD VDD) pmos w=2u l=100n
M44_S1_5_X1_nd_PB0 (x_nand_M44_S1_5_x1 VSS VDD VDD) pmos w=2u l=100n
M44_S1_5_X1_nd_NB0 (x_nand_M44_S1_5_x1 VSS nmid_M44_S1_5_X1_nd_0 VSS) nmos w=1u l=100n
M44_S1_5_X1_nd_NA0 (nmid_M44_S1_5_X1_nd_0 VSS VSS VSS) nmos w=1u l=100n
M44_S1_5_X1_na_PA0 (x_pre_M44_S1_5_x1 x_or_M44_S1_5_x1 VDD VDD) pmos w=2u l=100n
M44_S1_5_X1_na_PB0 (x_pre_M44_S1_5_x1 x_nand_M44_S1_5_x1 VDD VDD) pmos w=2u l=100n
M44_S1_5_X1_na_NB0 (x_pre_M44_S1_5_x1 x_nand_M44_S1_5_x1 nmid_M44_S1_5_X1_na_0 VSS) nmos w=1u l=100n
M44_S1_5_X1_na_NA0 (nmid_M44_S1_5_X1_na_0 x_or_M44_S1_5_x1 VSS VSS) nmos w=1u l=100n
M44_S1_5_X1_xo_P0 (M44_S1_5_xab x_pre_M44_S1_5_x1 VDD VDD) pmos w=2u l=100n
M44_S1_5_X1_xo_N0 (M44_S1_5_xab x_pre_M44_S1_5_x1 VSS VSS) nmos w=1u l=100n
M44_S1_5_X2_nr_PA0 (pmid_M44_S1_5_X2_nr_0 M44_S1_5_xab VDD VDD) pmos w=2u l=100n
M44_S1_5_X2_nr_PB0 (x_nor_M44_S1_5_x2 m44_c1_5 pmid_M44_S1_5_X2_nr_0 VDD) pmos w=2u l=100n
M44_S1_5_X2_nr_NA0 (x_nor_M44_S1_5_x2 M44_S1_5_xab VSS VSS) nmos w=1u l=100n
M44_S1_5_X2_nr_NB0 (x_nor_M44_S1_5_x2 m44_c1_5 VSS VSS) nmos w=1u l=100n
M44_S1_5_X2_iv_P0 (x_or_M44_S1_5_x2 x_nor_M44_S1_5_x2 VDD VDD) pmos w=2u l=100n
M44_S1_5_X2_iv_N0 (x_or_M44_S1_5_x2 x_nor_M44_S1_5_x2 VSS VSS) nmos w=1u l=100n
M44_S1_5_X2_nd_PA0 (x_nand_M44_S1_5_x2 M44_S1_5_xab VDD VDD) pmos w=2u l=100n
M44_S1_5_X2_nd_PB0 (x_nand_M44_S1_5_x2 m44_c1_5 VDD VDD) pmos w=2u l=100n
M44_S1_5_X2_nd_NB0 (x_nand_M44_S1_5_x2 m44_c1_5 nmid_M44_S1_5_X2_nd_0 VSS) nmos w=1u l=100n
M44_S1_5_X2_nd_NA0 (nmid_M44_S1_5_X2_nd_0 M44_S1_5_xab VSS VSS) nmos w=1u l=100n
M44_S1_5_X2_na_PA0 (x_pre_M44_S1_5_x2 x_or_M44_S1_5_x2 VDD VDD) pmos w=2u l=100n
M44_S1_5_X2_na_PB0 (x_pre_M44_S1_5_x2 x_nand_M44_S1_5_x2 VDD VDD) pmos w=2u l=100n
M44_S1_5_X2_na_NB0 (x_pre_M44_S1_5_x2 x_nand_M44_S1_5_x2 nmid_M44_S1_5_X2_na_0 VSS) nmos w=1u l=100n
M44_S1_5_X2_na_NA0 (nmid_M44_S1_5_X2_na_0 x_or_M44_S1_5_x2 VSS VSS) nmos w=1u l=100n
M44_S1_5_X2_xo_P0 (m44_s1_5 x_pre_M44_S1_5_x2 VDD VDD) pmos w=2u l=100n
M44_S1_5_X2_xo_N0 (m44_s1_5 x_pre_M44_S1_5_x2 VSS VSS) nmos w=1u l=100n
M44_S1_5_AB_N_PA0 (M44_S1_5_ab_n VSS VDD VDD) pmos w=2u l=100n
M44_S1_5_AB_N_PB0 (M44_S1_5_ab_n VSS VDD VDD) pmos w=2u l=100n
M44_S1_5_AB_N_NB0 (M44_S1_5_ab_n VSS nmid_M44_S1_5_AB_N_0 VSS) nmos w=1u l=100n
M44_S1_5_AB_N_NA0 (nmid_M44_S1_5_AB_N_0 VSS VSS VSS) nmos w=1u l=100n
M44_S1_5_AB_I_P0 (M44_S1_5_ab M44_S1_5_ab_n VDD VDD) pmos w=2u l=100n
M44_S1_5_AB_I_N0 (M44_S1_5_ab M44_S1_5_ab_n VSS VSS) nmos w=1u l=100n
M44_S1_5_XC_N_PA0 (M44_S1_5_xc_n M44_S1_5_xab VDD VDD) pmos w=2u l=100n
M44_S1_5_XC_N_PB0 (M44_S1_5_xc_n m44_c1_5 VDD VDD) pmos w=2u l=100n
M44_S1_5_XC_N_NB0 (M44_S1_5_xc_n m44_c1_5 nmid_M44_S1_5_XC_N_0 VSS) nmos w=1u l=100n
M44_S1_5_XC_N_NA0 (nmid_M44_S1_5_XC_N_0 M44_S1_5_xab VSS VSS) nmos w=1u l=100n
M44_S1_5_XC_I_P0 (M44_S1_5_xc M44_S1_5_xc_n VDD VDD) pmos w=2u l=100n
M44_S1_5_XC_I_N0 (M44_S1_5_xc M44_S1_5_xc_n VSS VSS) nmos w=1u l=100n
M44_S1_5_OR_N_PA0 (pmid_M44_S1_5_OR_N_0 M44_S1_5_ab VDD VDD) pmos w=2u l=100n
M44_S1_5_OR_N_PB0 (m44_c1_6_n M44_S1_5_xc pmid_M44_S1_5_OR_N_0 VDD) pmos w=2u l=100n
M44_S1_5_OR_N_NA0 (m44_c1_6_n M44_S1_5_ab VSS VSS) nmos w=1u l=100n
M44_S1_5_OR_N_NB0 (m44_c1_6_n M44_S1_5_xc VSS VSS) nmos w=1u l=100n
M44_S1_5_OR_I_P0 (m44_c1_6 m44_c1_6_n VDD VDD) pmos w=2u l=100n
M44_S1_5_OR_I_N0 (m44_c1_6 m44_c1_6_n VSS VSS) nmos w=1u l=100n
M44_S1_6_X1_nr_PA0 (pmid_M44_S1_6_X1_nr_0 VSS VDD VDD) pmos w=2u l=100n
M44_S1_6_X1_nr_PB0 (x_nor_M44_S1_6_x1 VSS pmid_M44_S1_6_X1_nr_0 VDD) pmos w=2u l=100n
M44_S1_6_X1_nr_NA0 (x_nor_M44_S1_6_x1 VSS VSS VSS) nmos w=1u l=100n
M44_S1_6_X1_nr_NB0 (x_nor_M44_S1_6_x1 VSS VSS VSS) nmos w=1u l=100n
M44_S1_6_X1_iv_P0 (x_or_M44_S1_6_x1 x_nor_M44_S1_6_x1 VDD VDD) pmos w=2u l=100n
M44_S1_6_X1_iv_N0 (x_or_M44_S1_6_x1 x_nor_M44_S1_6_x1 VSS VSS) nmos w=1u l=100n
M44_S1_6_X1_nd_PA0 (x_nand_M44_S1_6_x1 VSS VDD VDD) pmos w=2u l=100n
M44_S1_6_X1_nd_PB0 (x_nand_M44_S1_6_x1 VSS VDD VDD) pmos w=2u l=100n
M44_S1_6_X1_nd_NB0 (x_nand_M44_S1_6_x1 VSS nmid_M44_S1_6_X1_nd_0 VSS) nmos w=1u l=100n
M44_S1_6_X1_nd_NA0 (nmid_M44_S1_6_X1_nd_0 VSS VSS VSS) nmos w=1u l=100n
M44_S1_6_X1_na_PA0 (x_pre_M44_S1_6_x1 x_or_M44_S1_6_x1 VDD VDD) pmos w=2u l=100n
M44_S1_6_X1_na_PB0 (x_pre_M44_S1_6_x1 x_nand_M44_S1_6_x1 VDD VDD) pmos w=2u l=100n
M44_S1_6_X1_na_NB0 (x_pre_M44_S1_6_x1 x_nand_M44_S1_6_x1 nmid_M44_S1_6_X1_na_0 VSS) nmos w=1u l=100n
M44_S1_6_X1_na_NA0 (nmid_M44_S1_6_X1_na_0 x_or_M44_S1_6_x1 VSS VSS) nmos w=1u l=100n
M44_S1_6_X1_xo_P0 (M44_S1_6_xab x_pre_M44_S1_6_x1 VDD VDD) pmos w=2u l=100n
M44_S1_6_X1_xo_N0 (M44_S1_6_xab x_pre_M44_S1_6_x1 VSS VSS) nmos w=1u l=100n
M44_S1_6_X2_nr_PA0 (pmid_M44_S1_6_X2_nr_0 M44_S1_6_xab VDD VDD) pmos w=2u l=100n
M44_S1_6_X2_nr_PB0 (x_nor_M44_S1_6_x2 m44_c1_6 pmid_M44_S1_6_X2_nr_0 VDD) pmos w=2u l=100n
M44_S1_6_X2_nr_NA0 (x_nor_M44_S1_6_x2 M44_S1_6_xab VSS VSS) nmos w=1u l=100n
M44_S1_6_X2_nr_NB0 (x_nor_M44_S1_6_x2 m44_c1_6 VSS VSS) nmos w=1u l=100n
M44_S1_6_X2_iv_P0 (x_or_M44_S1_6_x2 x_nor_M44_S1_6_x2 VDD VDD) pmos w=2u l=100n
M44_S1_6_X2_iv_N0 (x_or_M44_S1_6_x2 x_nor_M44_S1_6_x2 VSS VSS) nmos w=1u l=100n
M44_S1_6_X2_nd_PA0 (x_nand_M44_S1_6_x2 M44_S1_6_xab VDD VDD) pmos w=2u l=100n
M44_S1_6_X2_nd_PB0 (x_nand_M44_S1_6_x2 m44_c1_6 VDD VDD) pmos w=2u l=100n
M44_S1_6_X2_nd_NB0 (x_nand_M44_S1_6_x2 m44_c1_6 nmid_M44_S1_6_X2_nd_0 VSS) nmos w=1u l=100n
M44_S1_6_X2_nd_NA0 (nmid_M44_S1_6_X2_nd_0 M44_S1_6_xab VSS VSS) nmos w=1u l=100n
M44_S1_6_X2_na_PA0 (x_pre_M44_S1_6_x2 x_or_M44_S1_6_x2 VDD VDD) pmos w=2u l=100n
M44_S1_6_X2_na_PB0 (x_pre_M44_S1_6_x2 x_nand_M44_S1_6_x2 VDD VDD) pmos w=2u l=100n
M44_S1_6_X2_na_NB0 (x_pre_M44_S1_6_x2 x_nand_M44_S1_6_x2 nmid_M44_S1_6_X2_na_0 VSS) nmos w=1u l=100n
M44_S1_6_X2_na_NA0 (nmid_M44_S1_6_X2_na_0 x_or_M44_S1_6_x2 VSS VSS) nmos w=1u l=100n
M44_S1_6_X2_xo_P0 (m44_s1_6 x_pre_M44_S1_6_x2 VDD VDD) pmos w=2u l=100n
M44_S1_6_X2_xo_N0 (m44_s1_6 x_pre_M44_S1_6_x2 VSS VSS) nmos w=1u l=100n
M44_S1_6_AB_N_PA0 (M44_S1_6_ab_n VSS VDD VDD) pmos w=2u l=100n
M44_S1_6_AB_N_PB0 (M44_S1_6_ab_n VSS VDD VDD) pmos w=2u l=100n
M44_S1_6_AB_N_NB0 (M44_S1_6_ab_n VSS nmid_M44_S1_6_AB_N_0 VSS) nmos w=1u l=100n
M44_S1_6_AB_N_NA0 (nmid_M44_S1_6_AB_N_0 VSS VSS VSS) nmos w=1u l=100n
M44_S1_6_AB_I_P0 (M44_S1_6_ab M44_S1_6_ab_n VDD VDD) pmos w=2u l=100n
M44_S1_6_AB_I_N0 (M44_S1_6_ab M44_S1_6_ab_n VSS VSS) nmos w=1u l=100n
M44_S1_6_XC_N_PA0 (M44_S1_6_xc_n M44_S1_6_xab VDD VDD) pmos w=2u l=100n
M44_S1_6_XC_N_PB0 (M44_S1_6_xc_n m44_c1_6 VDD VDD) pmos w=2u l=100n
M44_S1_6_XC_N_NB0 (M44_S1_6_xc_n m44_c1_6 nmid_M44_S1_6_XC_N_0 VSS) nmos w=1u l=100n
M44_S1_6_XC_N_NA0 (nmid_M44_S1_6_XC_N_0 M44_S1_6_xab VSS VSS) nmos w=1u l=100n
M44_S1_6_XC_I_P0 (M44_S1_6_xc M44_S1_6_xc_n VDD VDD) pmos w=2u l=100n
M44_S1_6_XC_I_N0 (M44_S1_6_xc M44_S1_6_xc_n VSS VSS) nmos w=1u l=100n
M44_S1_6_OR_N_PA0 (pmid_M44_S1_6_OR_N_0 M44_S1_6_ab VDD VDD) pmos w=2u l=100n
M44_S1_6_OR_N_PB0 (m44_c1_7_n M44_S1_6_xc pmid_M44_S1_6_OR_N_0 VDD) pmos w=2u l=100n
M44_S1_6_OR_N_NA0 (m44_c1_7_n M44_S1_6_ab VSS VSS) nmos w=1u l=100n
M44_S1_6_OR_N_NB0 (m44_c1_7_n M44_S1_6_xc VSS VSS) nmos w=1u l=100n
M44_S1_6_OR_I_P0 (m44_c1_7 m44_c1_7_n VDD VDD) pmos w=2u l=100n
M44_S1_6_OR_I_N0 (m44_c1_7 m44_c1_7_n VSS VSS) nmos w=1u l=100n
M44_S1_7_X1_nr_PA0 (pmid_M44_S1_7_X1_nr_0 VSS VDD VDD) pmos w=2u l=100n
M44_S1_7_X1_nr_PB0 (x_nor_M44_S1_7_x1 VSS pmid_M44_S1_7_X1_nr_0 VDD) pmos w=2u l=100n
M44_S1_7_X1_nr_NA0 (x_nor_M44_S1_7_x1 VSS VSS VSS) nmos w=1u l=100n
M44_S1_7_X1_nr_NB0 (x_nor_M44_S1_7_x1 VSS VSS VSS) nmos w=1u l=100n
M44_S1_7_X1_iv_P0 (x_or_M44_S1_7_x1 x_nor_M44_S1_7_x1 VDD VDD) pmos w=2u l=100n
M44_S1_7_X1_iv_N0 (x_or_M44_S1_7_x1 x_nor_M44_S1_7_x1 VSS VSS) nmos w=1u l=100n
M44_S1_7_X1_nd_PA0 (x_nand_M44_S1_7_x1 VSS VDD VDD) pmos w=2u l=100n
M44_S1_7_X1_nd_PB0 (x_nand_M44_S1_7_x1 VSS VDD VDD) pmos w=2u l=100n
M44_S1_7_X1_nd_NB0 (x_nand_M44_S1_7_x1 VSS nmid_M44_S1_7_X1_nd_0 VSS) nmos w=1u l=100n
M44_S1_7_X1_nd_NA0 (nmid_M44_S1_7_X1_nd_0 VSS VSS VSS) nmos w=1u l=100n
M44_S1_7_X1_na_PA0 (x_pre_M44_S1_7_x1 x_or_M44_S1_7_x1 VDD VDD) pmos w=2u l=100n
M44_S1_7_X1_na_PB0 (x_pre_M44_S1_7_x1 x_nand_M44_S1_7_x1 VDD VDD) pmos w=2u l=100n
M44_S1_7_X1_na_NB0 (x_pre_M44_S1_7_x1 x_nand_M44_S1_7_x1 nmid_M44_S1_7_X1_na_0 VSS) nmos w=1u l=100n
M44_S1_7_X1_na_NA0 (nmid_M44_S1_7_X1_na_0 x_or_M44_S1_7_x1 VSS VSS) nmos w=1u l=100n
M44_S1_7_X1_xo_P0 (M44_S1_7_xab x_pre_M44_S1_7_x1 VDD VDD) pmos w=2u l=100n
M44_S1_7_X1_xo_N0 (M44_S1_7_xab x_pre_M44_S1_7_x1 VSS VSS) nmos w=1u l=100n
M44_S1_7_X2_nr_PA0 (pmid_M44_S1_7_X2_nr_0 M44_S1_7_xab VDD VDD) pmos w=2u l=100n
M44_S1_7_X2_nr_PB0 (x_nor_M44_S1_7_x2 m44_c1_7 pmid_M44_S1_7_X2_nr_0 VDD) pmos w=2u l=100n
M44_S1_7_X2_nr_NA0 (x_nor_M44_S1_7_x2 M44_S1_7_xab VSS VSS) nmos w=1u l=100n
M44_S1_7_X2_nr_NB0 (x_nor_M44_S1_7_x2 m44_c1_7 VSS VSS) nmos w=1u l=100n
M44_S1_7_X2_iv_P0 (x_or_M44_S1_7_x2 x_nor_M44_S1_7_x2 VDD VDD) pmos w=2u l=100n
M44_S1_7_X2_iv_N0 (x_or_M44_S1_7_x2 x_nor_M44_S1_7_x2 VSS VSS) nmos w=1u l=100n
M44_S1_7_X2_nd_PA0 (x_nand_M44_S1_7_x2 M44_S1_7_xab VDD VDD) pmos w=2u l=100n
M44_S1_7_X2_nd_PB0 (x_nand_M44_S1_7_x2 m44_c1_7 VDD VDD) pmos w=2u l=100n
M44_S1_7_X2_nd_NB0 (x_nand_M44_S1_7_x2 m44_c1_7 nmid_M44_S1_7_X2_nd_0 VSS) nmos w=1u l=100n
M44_S1_7_X2_nd_NA0 (nmid_M44_S1_7_X2_nd_0 M44_S1_7_xab VSS VSS) nmos w=1u l=100n
M44_S1_7_X2_na_PA0 (x_pre_M44_S1_7_x2 x_or_M44_S1_7_x2 VDD VDD) pmos w=2u l=100n
M44_S1_7_X2_na_PB0 (x_pre_M44_S1_7_x2 x_nand_M44_S1_7_x2 VDD VDD) pmos w=2u l=100n
M44_S1_7_X2_na_NB0 (x_pre_M44_S1_7_x2 x_nand_M44_S1_7_x2 nmid_M44_S1_7_X2_na_0 VSS) nmos w=1u l=100n
M44_S1_7_X2_na_NA0 (nmid_M44_S1_7_X2_na_0 x_or_M44_S1_7_x2 VSS VSS) nmos w=1u l=100n
M44_S1_7_X2_xo_P0 (m44_s1_7 x_pre_M44_S1_7_x2 VDD VDD) pmos w=2u l=100n
M44_S1_7_X2_xo_N0 (m44_s1_7 x_pre_M44_S1_7_x2 VSS VSS) nmos w=1u l=100n
M44_S1_7_AB_N_PA0 (M44_S1_7_ab_n VSS VDD VDD) pmos w=2u l=100n
M44_S1_7_AB_N_PB0 (M44_S1_7_ab_n VSS VDD VDD) pmos w=2u l=100n
M44_S1_7_AB_N_NB0 (M44_S1_7_ab_n VSS nmid_M44_S1_7_AB_N_0 VSS) nmos w=1u l=100n
M44_S1_7_AB_N_NA0 (nmid_M44_S1_7_AB_N_0 VSS VSS VSS) nmos w=1u l=100n
M44_S1_7_AB_I_P0 (M44_S1_7_ab M44_S1_7_ab_n VDD VDD) pmos w=2u l=100n
M44_S1_7_AB_I_N0 (M44_S1_7_ab M44_S1_7_ab_n VSS VSS) nmos w=1u l=100n
M44_S1_7_XC_N_PA0 (M44_S1_7_xc_n M44_S1_7_xab VDD VDD) pmos w=2u l=100n
M44_S1_7_XC_N_PB0 (M44_S1_7_xc_n m44_c1_7 VDD VDD) pmos w=2u l=100n
M44_S1_7_XC_N_NB0 (M44_S1_7_xc_n m44_c1_7 nmid_M44_S1_7_XC_N_0 VSS) nmos w=1u l=100n
M44_S1_7_XC_N_NA0 (nmid_M44_S1_7_XC_N_0 M44_S1_7_xab VSS VSS) nmos w=1u l=100n
M44_S1_7_XC_I_P0 (M44_S1_7_xc M44_S1_7_xc_n VDD VDD) pmos w=2u l=100n
M44_S1_7_XC_I_N0 (M44_S1_7_xc M44_S1_7_xc_n VSS VSS) nmos w=1u l=100n
M44_S1_7_OR_N_PA0 (pmid_M44_S1_7_OR_N_0 M44_S1_7_ab VDD VDD) pmos w=2u l=100n
M44_S1_7_OR_N_PB0 (m44_c1_8_n M44_S1_7_xc pmid_M44_S1_7_OR_N_0 VDD) pmos w=2u l=100n
M44_S1_7_OR_N_NA0 (m44_c1_8_n M44_S1_7_ab VSS VSS) nmos w=1u l=100n
M44_S1_7_OR_N_NB0 (m44_c1_8_n M44_S1_7_xc VSS VSS) nmos w=1u l=100n
M44_S1_7_OR_I_P0 (m44_c1_8 m44_c1_8_n VDD VDD) pmos w=2u l=100n
M44_S1_7_OR_I_N0 (m44_c1_8 m44_c1_8_n VSS VSS) nmos w=1u l=100n
M44_S20_nr_PA0 (pmid_M44_S20_nr_0 m44_s1_0 VDD VDD) pmos w=2u l=100n
M44_S20_nr_PB0 (x_nor_m44s20 VSS pmid_M44_S20_nr_0 VDD) pmos w=2u l=100n
M44_S20_nr_NA0 (x_nor_m44s20 m44_s1_0 VSS VSS) nmos w=1u l=100n
M44_S20_nr_NB0 (x_nor_m44s20 VSS VSS VSS) nmos w=1u l=100n
M44_S20_iv_P0 (x_or_m44s20 x_nor_m44s20 VDD VDD) pmos w=2u l=100n
M44_S20_iv_N0 (x_or_m44s20 x_nor_m44s20 VSS VSS) nmos w=1u l=100n
M44_S20_nd_PA0 (x_nand_m44s20 m44_s1_0 VDD VDD) pmos w=2u l=100n
M44_S20_nd_PB0 (x_nand_m44s20 VSS VDD VDD) pmos w=2u l=100n
M44_S20_nd_NB0 (x_nand_m44s20 VSS nmid_M44_S20_nd_0 VSS) nmos w=1u l=100n
M44_S20_nd_NA0 (nmid_M44_S20_nd_0 m44_s1_0 VSS VSS) nmos w=1u l=100n
M44_S20_na_PA0 (x_pre_m44s20 x_or_m44s20 VDD VDD) pmos w=2u l=100n
M44_S20_na_PB0 (x_pre_m44s20 x_nand_m44s20 VDD VDD) pmos w=2u l=100n
M44_S20_na_NB0 (x_pre_m44s20 x_nand_m44s20 nmid_M44_S20_na_0 VSS) nmos w=1u l=100n
M44_S20_na_NA0 (nmid_M44_S20_na_0 x_or_m44s20 VSS VSS) nmos w=1u l=100n
M44_S20_xo_P0 (m44_s2_0 x_pre_m44s20 VDD VDD) pmos w=2u l=100n
M44_S20_xo_N0 (m44_s2_0 x_pre_m44s20 VSS VSS) nmos w=1u l=100n
M44_C21_N_PA0 (m44_c2_1_n m44_s1_0 VDD VDD) pmos w=2u l=100n
M44_C21_N_PB0 (m44_c2_1_n VSS VDD VDD) pmos w=2u l=100n
M44_C21_N_NB0 (m44_c2_1_n VSS nmid_M44_C21_N_0 VSS) nmos w=1u l=100n
M44_C21_N_NA0 (nmid_M44_C21_N_0 m44_s1_0 VSS VSS) nmos w=1u l=100n
M44_C21_I_P0 (m44_c2_1 m44_c2_1_n VDD VDD) pmos w=2u l=100n
M44_C21_I_N0 (m44_c2_1 m44_c2_1_n VSS VSS) nmos w=1u l=100n
M44_S2_1_X1_nr_PA0 (pmid_M44_S2_1_X1_nr_0 m44_s1_1 VDD VDD) pmos w=2u l=100n
M44_S2_1_X1_nr_PB0 (x_nor_M44_S2_1_x1 VSS pmid_M44_S2_1_X1_nr_0 VDD) pmos w=2u l=100n
M44_S2_1_X1_nr_NA0 (x_nor_M44_S2_1_x1 m44_s1_1 VSS VSS) nmos w=1u l=100n
M44_S2_1_X1_nr_NB0 (x_nor_M44_S2_1_x1 VSS VSS VSS) nmos w=1u l=100n
M44_S2_1_X1_iv_P0 (x_or_M44_S2_1_x1 x_nor_M44_S2_1_x1 VDD VDD) pmos w=2u l=100n
M44_S2_1_X1_iv_N0 (x_or_M44_S2_1_x1 x_nor_M44_S2_1_x1 VSS VSS) nmos w=1u l=100n
M44_S2_1_X1_nd_PA0 (x_nand_M44_S2_1_x1 m44_s1_1 VDD VDD) pmos w=2u l=100n
M44_S2_1_X1_nd_PB0 (x_nand_M44_S2_1_x1 VSS VDD VDD) pmos w=2u l=100n
M44_S2_1_X1_nd_NB0 (x_nand_M44_S2_1_x1 VSS nmid_M44_S2_1_X1_nd_0 VSS) nmos w=1u l=100n
M44_S2_1_X1_nd_NA0 (nmid_M44_S2_1_X1_nd_0 m44_s1_1 VSS VSS) nmos w=1u l=100n
M44_S2_1_X1_na_PA0 (x_pre_M44_S2_1_x1 x_or_M44_S2_1_x1 VDD VDD) pmos w=2u l=100n
M44_S2_1_X1_na_PB0 (x_pre_M44_S2_1_x1 x_nand_M44_S2_1_x1 VDD VDD) pmos w=2u l=100n
M44_S2_1_X1_na_NB0 (x_pre_M44_S2_1_x1 x_nand_M44_S2_1_x1 nmid_M44_S2_1_X1_na_0 VSS) nmos w=1u l=100n
M44_S2_1_X1_na_NA0 (nmid_M44_S2_1_X1_na_0 x_or_M44_S2_1_x1 VSS VSS) nmos w=1u l=100n
M44_S2_1_X1_xo_P0 (M44_S2_1_xab x_pre_M44_S2_1_x1 VDD VDD) pmos w=2u l=100n
M44_S2_1_X1_xo_N0 (M44_S2_1_xab x_pre_M44_S2_1_x1 VSS VSS) nmos w=1u l=100n
M44_S2_1_X2_nr_PA0 (pmid_M44_S2_1_X2_nr_0 M44_S2_1_xab VDD VDD) pmos w=2u l=100n
M44_S2_1_X2_nr_PB0 (x_nor_M44_S2_1_x2 m44_c2_1 pmid_M44_S2_1_X2_nr_0 VDD) pmos w=2u l=100n
M44_S2_1_X2_nr_NA0 (x_nor_M44_S2_1_x2 M44_S2_1_xab VSS VSS) nmos w=1u l=100n
M44_S2_1_X2_nr_NB0 (x_nor_M44_S2_1_x2 m44_c2_1 VSS VSS) nmos w=1u l=100n
M44_S2_1_X2_iv_P0 (x_or_M44_S2_1_x2 x_nor_M44_S2_1_x2 VDD VDD) pmos w=2u l=100n
M44_S2_1_X2_iv_N0 (x_or_M44_S2_1_x2 x_nor_M44_S2_1_x2 VSS VSS) nmos w=1u l=100n
M44_S2_1_X2_nd_PA0 (x_nand_M44_S2_1_x2 M44_S2_1_xab VDD VDD) pmos w=2u l=100n
M44_S2_1_X2_nd_PB0 (x_nand_M44_S2_1_x2 m44_c2_1 VDD VDD) pmos w=2u l=100n
M44_S2_1_X2_nd_NB0 (x_nand_M44_S2_1_x2 m44_c2_1 nmid_M44_S2_1_X2_nd_0 VSS) nmos w=1u l=100n
M44_S2_1_X2_nd_NA0 (nmid_M44_S2_1_X2_nd_0 M44_S2_1_xab VSS VSS) nmos w=1u l=100n
M44_S2_1_X2_na_PA0 (x_pre_M44_S2_1_x2 x_or_M44_S2_1_x2 VDD VDD) pmos w=2u l=100n
M44_S2_1_X2_na_PB0 (x_pre_M44_S2_1_x2 x_nand_M44_S2_1_x2 VDD VDD) pmos w=2u l=100n
M44_S2_1_X2_na_NB0 (x_pre_M44_S2_1_x2 x_nand_M44_S2_1_x2 nmid_M44_S2_1_X2_na_0 VSS) nmos w=1u l=100n
M44_S2_1_X2_na_NA0 (nmid_M44_S2_1_X2_na_0 x_or_M44_S2_1_x2 VSS VSS) nmos w=1u l=100n
M44_S2_1_X2_xo_P0 (m44_s2_1 x_pre_M44_S2_1_x2 VDD VDD) pmos w=2u l=100n
M44_S2_1_X2_xo_N0 (m44_s2_1 x_pre_M44_S2_1_x2 VSS VSS) nmos w=1u l=100n
M44_S2_1_AB_N_PA0 (M44_S2_1_ab_n m44_s1_1 VDD VDD) pmos w=2u l=100n
M44_S2_1_AB_N_PB0 (M44_S2_1_ab_n VSS VDD VDD) pmos w=2u l=100n
M44_S2_1_AB_N_NB0 (M44_S2_1_ab_n VSS nmid_M44_S2_1_AB_N_0 VSS) nmos w=1u l=100n
M44_S2_1_AB_N_NA0 (nmid_M44_S2_1_AB_N_0 m44_s1_1 VSS VSS) nmos w=1u l=100n
M44_S2_1_AB_I_P0 (M44_S2_1_ab M44_S2_1_ab_n VDD VDD) pmos w=2u l=100n
M44_S2_1_AB_I_N0 (M44_S2_1_ab M44_S2_1_ab_n VSS VSS) nmos w=1u l=100n
M44_S2_1_XC_N_PA0 (M44_S2_1_xc_n M44_S2_1_xab VDD VDD) pmos w=2u l=100n
M44_S2_1_XC_N_PB0 (M44_S2_1_xc_n m44_c2_1 VDD VDD) pmos w=2u l=100n
M44_S2_1_XC_N_NB0 (M44_S2_1_xc_n m44_c2_1 nmid_M44_S2_1_XC_N_0 VSS) nmos w=1u l=100n
M44_S2_1_XC_N_NA0 (nmid_M44_S2_1_XC_N_0 M44_S2_1_xab VSS VSS) nmos w=1u l=100n
M44_S2_1_XC_I_P0 (M44_S2_1_xc M44_S2_1_xc_n VDD VDD) pmos w=2u l=100n
M44_S2_1_XC_I_N0 (M44_S2_1_xc M44_S2_1_xc_n VSS VSS) nmos w=1u l=100n
M44_S2_1_OR_N_PA0 (pmid_M44_S2_1_OR_N_0 M44_S2_1_ab VDD VDD) pmos w=2u l=100n
M44_S2_1_OR_N_PB0 (m44_c2_2_n M44_S2_1_xc pmid_M44_S2_1_OR_N_0 VDD) pmos w=2u l=100n
M44_S2_1_OR_N_NA0 (m44_c2_2_n M44_S2_1_ab VSS VSS) nmos w=1u l=100n
M44_S2_1_OR_N_NB0 (m44_c2_2_n M44_S2_1_xc VSS VSS) nmos w=1u l=100n
M44_S2_1_OR_I_P0 (m44_c2_2 m44_c2_2_n VDD VDD) pmos w=2u l=100n
M44_S2_1_OR_I_N0 (m44_c2_2 m44_c2_2_n VSS VSS) nmos w=1u l=100n
M44_S2_2_X1_nr_PA0 (pmid_M44_S2_2_X1_nr_0 m44_s1_2 VDD VDD) pmos w=2u l=100n
M44_S2_2_X1_nr_PB0 (x_nor_M44_S2_2_x1 m44_pp02 pmid_M44_S2_2_X1_nr_0 VDD) pmos w=2u l=100n
M44_S2_2_X1_nr_NA0 (x_nor_M44_S2_2_x1 m44_s1_2 VSS VSS) nmos w=1u l=100n
M44_S2_2_X1_nr_NB0 (x_nor_M44_S2_2_x1 m44_pp02 VSS VSS) nmos w=1u l=100n
M44_S2_2_X1_iv_P0 (x_or_M44_S2_2_x1 x_nor_M44_S2_2_x1 VDD VDD) pmos w=2u l=100n
M44_S2_2_X1_iv_N0 (x_or_M44_S2_2_x1 x_nor_M44_S2_2_x1 VSS VSS) nmos w=1u l=100n
M44_S2_2_X1_nd_PA0 (x_nand_M44_S2_2_x1 m44_s1_2 VDD VDD) pmos w=2u l=100n
M44_S2_2_X1_nd_PB0 (x_nand_M44_S2_2_x1 m44_pp02 VDD VDD) pmos w=2u l=100n
M44_S2_2_X1_nd_NB0 (x_nand_M44_S2_2_x1 m44_pp02 nmid_M44_S2_2_X1_nd_0 VSS) nmos w=1u l=100n
M44_S2_2_X1_nd_NA0 (nmid_M44_S2_2_X1_nd_0 m44_s1_2 VSS VSS) nmos w=1u l=100n
M44_S2_2_X1_na_PA0 (x_pre_M44_S2_2_x1 x_or_M44_S2_2_x1 VDD VDD) pmos w=2u l=100n
M44_S2_2_X1_na_PB0 (x_pre_M44_S2_2_x1 x_nand_M44_S2_2_x1 VDD VDD) pmos w=2u l=100n
M44_S2_2_X1_na_NB0 (x_pre_M44_S2_2_x1 x_nand_M44_S2_2_x1 nmid_M44_S2_2_X1_na_0 VSS) nmos w=1u l=100n
M44_S2_2_X1_na_NA0 (nmid_M44_S2_2_X1_na_0 x_or_M44_S2_2_x1 VSS VSS) nmos w=1u l=100n
M44_S2_2_X1_xo_P0 (M44_S2_2_xab x_pre_M44_S2_2_x1 VDD VDD) pmos w=2u l=100n
M44_S2_2_X1_xo_N0 (M44_S2_2_xab x_pre_M44_S2_2_x1 VSS VSS) nmos w=1u l=100n
M44_S2_2_X2_nr_PA0 (pmid_M44_S2_2_X2_nr_0 M44_S2_2_xab VDD VDD) pmos w=2u l=100n
M44_S2_2_X2_nr_PB0 (x_nor_M44_S2_2_x2 m44_c2_2 pmid_M44_S2_2_X2_nr_0 VDD) pmos w=2u l=100n
M44_S2_2_X2_nr_NA0 (x_nor_M44_S2_2_x2 M44_S2_2_xab VSS VSS) nmos w=1u l=100n
M44_S2_2_X2_nr_NB0 (x_nor_M44_S2_2_x2 m44_c2_2 VSS VSS) nmos w=1u l=100n
M44_S2_2_X2_iv_P0 (x_or_M44_S2_2_x2 x_nor_M44_S2_2_x2 VDD VDD) pmos w=2u l=100n
M44_S2_2_X2_iv_N0 (x_or_M44_S2_2_x2 x_nor_M44_S2_2_x2 VSS VSS) nmos w=1u l=100n
M44_S2_2_X2_nd_PA0 (x_nand_M44_S2_2_x2 M44_S2_2_xab VDD VDD) pmos w=2u l=100n
M44_S2_2_X2_nd_PB0 (x_nand_M44_S2_2_x2 m44_c2_2 VDD VDD) pmos w=2u l=100n
M44_S2_2_X2_nd_NB0 (x_nand_M44_S2_2_x2 m44_c2_2 nmid_M44_S2_2_X2_nd_0 VSS) nmos w=1u l=100n
M44_S2_2_X2_nd_NA0 (nmid_M44_S2_2_X2_nd_0 M44_S2_2_xab VSS VSS) nmos w=1u l=100n
M44_S2_2_X2_na_PA0 (x_pre_M44_S2_2_x2 x_or_M44_S2_2_x2 VDD VDD) pmos w=2u l=100n
M44_S2_2_X2_na_PB0 (x_pre_M44_S2_2_x2 x_nand_M44_S2_2_x2 VDD VDD) pmos w=2u l=100n
M44_S2_2_X2_na_NB0 (x_pre_M44_S2_2_x2 x_nand_M44_S2_2_x2 nmid_M44_S2_2_X2_na_0 VSS) nmos w=1u l=100n
M44_S2_2_X2_na_NA0 (nmid_M44_S2_2_X2_na_0 x_or_M44_S2_2_x2 VSS VSS) nmos w=1u l=100n
M44_S2_2_X2_xo_P0 (m44_s2_2 x_pre_M44_S2_2_x2 VDD VDD) pmos w=2u l=100n
M44_S2_2_X2_xo_N0 (m44_s2_2 x_pre_M44_S2_2_x2 VSS VSS) nmos w=1u l=100n
M44_S2_2_AB_N_PA0 (M44_S2_2_ab_n m44_s1_2 VDD VDD) pmos w=2u l=100n
M44_S2_2_AB_N_PB0 (M44_S2_2_ab_n m44_pp02 VDD VDD) pmos w=2u l=100n
M44_S2_2_AB_N_NB0 (M44_S2_2_ab_n m44_pp02 nmid_M44_S2_2_AB_N_0 VSS) nmos w=1u l=100n
M44_S2_2_AB_N_NA0 (nmid_M44_S2_2_AB_N_0 m44_s1_2 VSS VSS) nmos w=1u l=100n
M44_S2_2_AB_I_P0 (M44_S2_2_ab M44_S2_2_ab_n VDD VDD) pmos w=2u l=100n
M44_S2_2_AB_I_N0 (M44_S2_2_ab M44_S2_2_ab_n VSS VSS) nmos w=1u l=100n
M44_S2_2_XC_N_PA0 (M44_S2_2_xc_n M44_S2_2_xab VDD VDD) pmos w=2u l=100n
M44_S2_2_XC_N_PB0 (M44_S2_2_xc_n m44_c2_2 VDD VDD) pmos w=2u l=100n
M44_S2_2_XC_N_NB0 (M44_S2_2_xc_n m44_c2_2 nmid_M44_S2_2_XC_N_0 VSS) nmos w=1u l=100n
M44_S2_2_XC_N_NA0 (nmid_M44_S2_2_XC_N_0 M44_S2_2_xab VSS VSS) nmos w=1u l=100n
M44_S2_2_XC_I_P0 (M44_S2_2_xc M44_S2_2_xc_n VDD VDD) pmos w=2u l=100n
M44_S2_2_XC_I_N0 (M44_S2_2_xc M44_S2_2_xc_n VSS VSS) nmos w=1u l=100n
M44_S2_2_OR_N_PA0 (pmid_M44_S2_2_OR_N_0 M44_S2_2_ab VDD VDD) pmos w=2u l=100n
M44_S2_2_OR_N_PB0 (m44_c2_3_n M44_S2_2_xc pmid_M44_S2_2_OR_N_0 VDD) pmos w=2u l=100n
M44_S2_2_OR_N_NA0 (m44_c2_3_n M44_S2_2_ab VSS VSS) nmos w=1u l=100n
M44_S2_2_OR_N_NB0 (m44_c2_3_n M44_S2_2_xc VSS VSS) nmos w=1u l=100n
M44_S2_2_OR_I_P0 (m44_c2_3 m44_c2_3_n VDD VDD) pmos w=2u l=100n
M44_S2_2_OR_I_N0 (m44_c2_3 m44_c2_3_n VSS VSS) nmos w=1u l=100n
M44_S2_3_X1_nr_PA0 (pmid_M44_S2_3_X1_nr_0 m44_s1_3 VDD VDD) pmos w=2u l=100n
M44_S2_3_X1_nr_PB0 (x_nor_M44_S2_3_x1 m44_pp12 pmid_M44_S2_3_X1_nr_0 VDD) pmos w=2u l=100n
M44_S2_3_X1_nr_NA0 (x_nor_M44_S2_3_x1 m44_s1_3 VSS VSS) nmos w=1u l=100n
M44_S2_3_X1_nr_NB0 (x_nor_M44_S2_3_x1 m44_pp12 VSS VSS) nmos w=1u l=100n
M44_S2_3_X1_iv_P0 (x_or_M44_S2_3_x1 x_nor_M44_S2_3_x1 VDD VDD) pmos w=2u l=100n
M44_S2_3_X1_iv_N0 (x_or_M44_S2_3_x1 x_nor_M44_S2_3_x1 VSS VSS) nmos w=1u l=100n
M44_S2_3_X1_nd_PA0 (x_nand_M44_S2_3_x1 m44_s1_3 VDD VDD) pmos w=2u l=100n
M44_S2_3_X1_nd_PB0 (x_nand_M44_S2_3_x1 m44_pp12 VDD VDD) pmos w=2u l=100n
M44_S2_3_X1_nd_NB0 (x_nand_M44_S2_3_x1 m44_pp12 nmid_M44_S2_3_X1_nd_0 VSS) nmos w=1u l=100n
M44_S2_3_X1_nd_NA0 (nmid_M44_S2_3_X1_nd_0 m44_s1_3 VSS VSS) nmos w=1u l=100n
M44_S2_3_X1_na_PA0 (x_pre_M44_S2_3_x1 x_or_M44_S2_3_x1 VDD VDD) pmos w=2u l=100n
M44_S2_3_X1_na_PB0 (x_pre_M44_S2_3_x1 x_nand_M44_S2_3_x1 VDD VDD) pmos w=2u l=100n
M44_S2_3_X1_na_NB0 (x_pre_M44_S2_3_x1 x_nand_M44_S2_3_x1 nmid_M44_S2_3_X1_na_0 VSS) nmos w=1u l=100n
M44_S2_3_X1_na_NA0 (nmid_M44_S2_3_X1_na_0 x_or_M44_S2_3_x1 VSS VSS) nmos w=1u l=100n
M44_S2_3_X1_xo_P0 (M44_S2_3_xab x_pre_M44_S2_3_x1 VDD VDD) pmos w=2u l=100n
M44_S2_3_X1_xo_N0 (M44_S2_3_xab x_pre_M44_S2_3_x1 VSS VSS) nmos w=1u l=100n
M44_S2_3_X2_nr_PA0 (pmid_M44_S2_3_X2_nr_0 M44_S2_3_xab VDD VDD) pmos w=2u l=100n
M44_S2_3_X2_nr_PB0 (x_nor_M44_S2_3_x2 m44_c2_3 pmid_M44_S2_3_X2_nr_0 VDD) pmos w=2u l=100n
M44_S2_3_X2_nr_NA0 (x_nor_M44_S2_3_x2 M44_S2_3_xab VSS VSS) nmos w=1u l=100n
M44_S2_3_X2_nr_NB0 (x_nor_M44_S2_3_x2 m44_c2_3 VSS VSS) nmos w=1u l=100n
M44_S2_3_X2_iv_P0 (x_or_M44_S2_3_x2 x_nor_M44_S2_3_x2 VDD VDD) pmos w=2u l=100n
M44_S2_3_X2_iv_N0 (x_or_M44_S2_3_x2 x_nor_M44_S2_3_x2 VSS VSS) nmos w=1u l=100n
M44_S2_3_X2_nd_PA0 (x_nand_M44_S2_3_x2 M44_S2_3_xab VDD VDD) pmos w=2u l=100n
M44_S2_3_X2_nd_PB0 (x_nand_M44_S2_3_x2 m44_c2_3 VDD VDD) pmos w=2u l=100n
M44_S2_3_X2_nd_NB0 (x_nand_M44_S2_3_x2 m44_c2_3 nmid_M44_S2_3_X2_nd_0 VSS) nmos w=1u l=100n
M44_S2_3_X2_nd_NA0 (nmid_M44_S2_3_X2_nd_0 M44_S2_3_xab VSS VSS) nmos w=1u l=100n
M44_S2_3_X2_na_PA0 (x_pre_M44_S2_3_x2 x_or_M44_S2_3_x2 VDD VDD) pmos w=2u l=100n
M44_S2_3_X2_na_PB0 (x_pre_M44_S2_3_x2 x_nand_M44_S2_3_x2 VDD VDD) pmos w=2u l=100n
M44_S2_3_X2_na_NB0 (x_pre_M44_S2_3_x2 x_nand_M44_S2_3_x2 nmid_M44_S2_3_X2_na_0 VSS) nmos w=1u l=100n
M44_S2_3_X2_na_NA0 (nmid_M44_S2_3_X2_na_0 x_or_M44_S2_3_x2 VSS VSS) nmos w=1u l=100n
M44_S2_3_X2_xo_P0 (m44_s2_3 x_pre_M44_S2_3_x2 VDD VDD) pmos w=2u l=100n
M44_S2_3_X2_xo_N0 (m44_s2_3 x_pre_M44_S2_3_x2 VSS VSS) nmos w=1u l=100n
M44_S2_3_AB_N_PA0 (M44_S2_3_ab_n m44_s1_3 VDD VDD) pmos w=2u l=100n
M44_S2_3_AB_N_PB0 (M44_S2_3_ab_n m44_pp12 VDD VDD) pmos w=2u l=100n
M44_S2_3_AB_N_NB0 (M44_S2_3_ab_n m44_pp12 nmid_M44_S2_3_AB_N_0 VSS) nmos w=1u l=100n
M44_S2_3_AB_N_NA0 (nmid_M44_S2_3_AB_N_0 m44_s1_3 VSS VSS) nmos w=1u l=100n
M44_S2_3_AB_I_P0 (M44_S2_3_ab M44_S2_3_ab_n VDD VDD) pmos w=2u l=100n
M44_S2_3_AB_I_N0 (M44_S2_3_ab M44_S2_3_ab_n VSS VSS) nmos w=1u l=100n
M44_S2_3_XC_N_PA0 (M44_S2_3_xc_n M44_S2_3_xab VDD VDD) pmos w=2u l=100n
M44_S2_3_XC_N_PB0 (M44_S2_3_xc_n m44_c2_3 VDD VDD) pmos w=2u l=100n
M44_S2_3_XC_N_NB0 (M44_S2_3_xc_n m44_c2_3 nmid_M44_S2_3_XC_N_0 VSS) nmos w=1u l=100n
M44_S2_3_XC_N_NA0 (nmid_M44_S2_3_XC_N_0 M44_S2_3_xab VSS VSS) nmos w=1u l=100n
M44_S2_3_XC_I_P0 (M44_S2_3_xc M44_S2_3_xc_n VDD VDD) pmos w=2u l=100n
M44_S2_3_XC_I_N0 (M44_S2_3_xc M44_S2_3_xc_n VSS VSS) nmos w=1u l=100n
M44_S2_3_OR_N_PA0 (pmid_M44_S2_3_OR_N_0 M44_S2_3_ab VDD VDD) pmos w=2u l=100n
M44_S2_3_OR_N_PB0 (m44_c2_4_n M44_S2_3_xc pmid_M44_S2_3_OR_N_0 VDD) pmos w=2u l=100n
M44_S2_3_OR_N_NA0 (m44_c2_4_n M44_S2_3_ab VSS VSS) nmos w=1u l=100n
M44_S2_3_OR_N_NB0 (m44_c2_4_n M44_S2_3_xc VSS VSS) nmos w=1u l=100n
M44_S2_3_OR_I_P0 (m44_c2_4 m44_c2_4_n VDD VDD) pmos w=2u l=100n
M44_S2_3_OR_I_N0 (m44_c2_4 m44_c2_4_n VSS VSS) nmos w=1u l=100n
M44_S2_4_X1_nr_PA0 (pmid_M44_S2_4_X1_nr_0 m44_s1_4 VDD VDD) pmos w=2u l=100n
M44_S2_4_X1_nr_PB0 (x_nor_M44_S2_4_x1 m44_pp22 pmid_M44_S2_4_X1_nr_0 VDD) pmos w=2u l=100n
M44_S2_4_X1_nr_NA0 (x_nor_M44_S2_4_x1 m44_s1_4 VSS VSS) nmos w=1u l=100n
M44_S2_4_X1_nr_NB0 (x_nor_M44_S2_4_x1 m44_pp22 VSS VSS) nmos w=1u l=100n
M44_S2_4_X1_iv_P0 (x_or_M44_S2_4_x1 x_nor_M44_S2_4_x1 VDD VDD) pmos w=2u l=100n
M44_S2_4_X1_iv_N0 (x_or_M44_S2_4_x1 x_nor_M44_S2_4_x1 VSS VSS) nmos w=1u l=100n
M44_S2_4_X1_nd_PA0 (x_nand_M44_S2_4_x1 m44_s1_4 VDD VDD) pmos w=2u l=100n
M44_S2_4_X1_nd_PB0 (x_nand_M44_S2_4_x1 m44_pp22 VDD VDD) pmos w=2u l=100n
M44_S2_4_X1_nd_NB0 (x_nand_M44_S2_4_x1 m44_pp22 nmid_M44_S2_4_X1_nd_0 VSS) nmos w=1u l=100n
M44_S2_4_X1_nd_NA0 (nmid_M44_S2_4_X1_nd_0 m44_s1_4 VSS VSS) nmos w=1u l=100n
M44_S2_4_X1_na_PA0 (x_pre_M44_S2_4_x1 x_or_M44_S2_4_x1 VDD VDD) pmos w=2u l=100n
M44_S2_4_X1_na_PB0 (x_pre_M44_S2_4_x1 x_nand_M44_S2_4_x1 VDD VDD) pmos w=2u l=100n
M44_S2_4_X1_na_NB0 (x_pre_M44_S2_4_x1 x_nand_M44_S2_4_x1 nmid_M44_S2_4_X1_na_0 VSS) nmos w=1u l=100n
M44_S2_4_X1_na_NA0 (nmid_M44_S2_4_X1_na_0 x_or_M44_S2_4_x1 VSS VSS) nmos w=1u l=100n
M44_S2_4_X1_xo_P0 (M44_S2_4_xab x_pre_M44_S2_4_x1 VDD VDD) pmos w=2u l=100n
M44_S2_4_X1_xo_N0 (M44_S2_4_xab x_pre_M44_S2_4_x1 VSS VSS) nmos w=1u l=100n
M44_S2_4_X2_nr_PA0 (pmid_M44_S2_4_X2_nr_0 M44_S2_4_xab VDD VDD) pmos w=2u l=100n
M44_S2_4_X2_nr_PB0 (x_nor_M44_S2_4_x2 m44_c2_4 pmid_M44_S2_4_X2_nr_0 VDD) pmos w=2u l=100n
M44_S2_4_X2_nr_NA0 (x_nor_M44_S2_4_x2 M44_S2_4_xab VSS VSS) nmos w=1u l=100n
M44_S2_4_X2_nr_NB0 (x_nor_M44_S2_4_x2 m44_c2_4 VSS VSS) nmos w=1u l=100n
M44_S2_4_X2_iv_P0 (x_or_M44_S2_4_x2 x_nor_M44_S2_4_x2 VDD VDD) pmos w=2u l=100n
M44_S2_4_X2_iv_N0 (x_or_M44_S2_4_x2 x_nor_M44_S2_4_x2 VSS VSS) nmos w=1u l=100n
M44_S2_4_X2_nd_PA0 (x_nand_M44_S2_4_x2 M44_S2_4_xab VDD VDD) pmos w=2u l=100n
M44_S2_4_X2_nd_PB0 (x_nand_M44_S2_4_x2 m44_c2_4 VDD VDD) pmos w=2u l=100n
M44_S2_4_X2_nd_NB0 (x_nand_M44_S2_4_x2 m44_c2_4 nmid_M44_S2_4_X2_nd_0 VSS) nmos w=1u l=100n
M44_S2_4_X2_nd_NA0 (nmid_M44_S2_4_X2_nd_0 M44_S2_4_xab VSS VSS) nmos w=1u l=100n
M44_S2_4_X2_na_PA0 (x_pre_M44_S2_4_x2 x_or_M44_S2_4_x2 VDD VDD) pmos w=2u l=100n
M44_S2_4_X2_na_PB0 (x_pre_M44_S2_4_x2 x_nand_M44_S2_4_x2 VDD VDD) pmos w=2u l=100n
M44_S2_4_X2_na_NB0 (x_pre_M44_S2_4_x2 x_nand_M44_S2_4_x2 nmid_M44_S2_4_X2_na_0 VSS) nmos w=1u l=100n
M44_S2_4_X2_na_NA0 (nmid_M44_S2_4_X2_na_0 x_or_M44_S2_4_x2 VSS VSS) nmos w=1u l=100n
M44_S2_4_X2_xo_P0 (m44_s2_4 x_pre_M44_S2_4_x2 VDD VDD) pmos w=2u l=100n
M44_S2_4_X2_xo_N0 (m44_s2_4 x_pre_M44_S2_4_x2 VSS VSS) nmos w=1u l=100n
M44_S2_4_AB_N_PA0 (M44_S2_4_ab_n m44_s1_4 VDD VDD) pmos w=2u l=100n
M44_S2_4_AB_N_PB0 (M44_S2_4_ab_n m44_pp22 VDD VDD) pmos w=2u l=100n
M44_S2_4_AB_N_NB0 (M44_S2_4_ab_n m44_pp22 nmid_M44_S2_4_AB_N_0 VSS) nmos w=1u l=100n
M44_S2_4_AB_N_NA0 (nmid_M44_S2_4_AB_N_0 m44_s1_4 VSS VSS) nmos w=1u l=100n
M44_S2_4_AB_I_P0 (M44_S2_4_ab M44_S2_4_ab_n VDD VDD) pmos w=2u l=100n
M44_S2_4_AB_I_N0 (M44_S2_4_ab M44_S2_4_ab_n VSS VSS) nmos w=1u l=100n
M44_S2_4_XC_N_PA0 (M44_S2_4_xc_n M44_S2_4_xab VDD VDD) pmos w=2u l=100n
M44_S2_4_XC_N_PB0 (M44_S2_4_xc_n m44_c2_4 VDD VDD) pmos w=2u l=100n
M44_S2_4_XC_N_NB0 (M44_S2_4_xc_n m44_c2_4 nmid_M44_S2_4_XC_N_0 VSS) nmos w=1u l=100n
M44_S2_4_XC_N_NA0 (nmid_M44_S2_4_XC_N_0 M44_S2_4_xab VSS VSS) nmos w=1u l=100n
M44_S2_4_XC_I_P0 (M44_S2_4_xc M44_S2_4_xc_n VDD VDD) pmos w=2u l=100n
M44_S2_4_XC_I_N0 (M44_S2_4_xc M44_S2_4_xc_n VSS VSS) nmos w=1u l=100n
M44_S2_4_OR_N_PA0 (pmid_M44_S2_4_OR_N_0 M44_S2_4_ab VDD VDD) pmos w=2u l=100n
M44_S2_4_OR_N_PB0 (m44_c2_5_n M44_S2_4_xc pmid_M44_S2_4_OR_N_0 VDD) pmos w=2u l=100n
M44_S2_4_OR_N_NA0 (m44_c2_5_n M44_S2_4_ab VSS VSS) nmos w=1u l=100n
M44_S2_4_OR_N_NB0 (m44_c2_5_n M44_S2_4_xc VSS VSS) nmos w=1u l=100n
M44_S2_4_OR_I_P0 (m44_c2_5 m44_c2_5_n VDD VDD) pmos w=2u l=100n
M44_S2_4_OR_I_N0 (m44_c2_5 m44_c2_5_n VSS VSS) nmos w=1u l=100n
M44_S2_5_X1_nr_PA0 (pmid_M44_S2_5_X1_nr_0 m44_s1_5 VDD VDD) pmos w=2u l=100n
M44_S2_5_X1_nr_PB0 (x_nor_M44_S2_5_x1 m44_pp32 pmid_M44_S2_5_X1_nr_0 VDD) pmos w=2u l=100n
M44_S2_5_X1_nr_NA0 (x_nor_M44_S2_5_x1 m44_s1_5 VSS VSS) nmos w=1u l=100n
M44_S2_5_X1_nr_NB0 (x_nor_M44_S2_5_x1 m44_pp32 VSS VSS) nmos w=1u l=100n
M44_S2_5_X1_iv_P0 (x_or_M44_S2_5_x1 x_nor_M44_S2_5_x1 VDD VDD) pmos w=2u l=100n
M44_S2_5_X1_iv_N0 (x_or_M44_S2_5_x1 x_nor_M44_S2_5_x1 VSS VSS) nmos w=1u l=100n
M44_S2_5_X1_nd_PA0 (x_nand_M44_S2_5_x1 m44_s1_5 VDD VDD) pmos w=2u l=100n
M44_S2_5_X1_nd_PB0 (x_nand_M44_S2_5_x1 m44_pp32 VDD VDD) pmos w=2u l=100n
M44_S2_5_X1_nd_NB0 (x_nand_M44_S2_5_x1 m44_pp32 nmid_M44_S2_5_X1_nd_0 VSS) nmos w=1u l=100n
M44_S2_5_X1_nd_NA0 (nmid_M44_S2_5_X1_nd_0 m44_s1_5 VSS VSS) nmos w=1u l=100n
M44_S2_5_X1_na_PA0 (x_pre_M44_S2_5_x1 x_or_M44_S2_5_x1 VDD VDD) pmos w=2u l=100n
M44_S2_5_X1_na_PB0 (x_pre_M44_S2_5_x1 x_nand_M44_S2_5_x1 VDD VDD) pmos w=2u l=100n
M44_S2_5_X1_na_NB0 (x_pre_M44_S2_5_x1 x_nand_M44_S2_5_x1 nmid_M44_S2_5_X1_na_0 VSS) nmos w=1u l=100n
M44_S2_5_X1_na_NA0 (nmid_M44_S2_5_X1_na_0 x_or_M44_S2_5_x1 VSS VSS) nmos w=1u l=100n
M44_S2_5_X1_xo_P0 (M44_S2_5_xab x_pre_M44_S2_5_x1 VDD VDD) pmos w=2u l=100n
M44_S2_5_X1_xo_N0 (M44_S2_5_xab x_pre_M44_S2_5_x1 VSS VSS) nmos w=1u l=100n
M44_S2_5_X2_nr_PA0 (pmid_M44_S2_5_X2_nr_0 M44_S2_5_xab VDD VDD) pmos w=2u l=100n
M44_S2_5_X2_nr_PB0 (x_nor_M44_S2_5_x2 m44_c2_5 pmid_M44_S2_5_X2_nr_0 VDD) pmos w=2u l=100n
M44_S2_5_X2_nr_NA0 (x_nor_M44_S2_5_x2 M44_S2_5_xab VSS VSS) nmos w=1u l=100n
M44_S2_5_X2_nr_NB0 (x_nor_M44_S2_5_x2 m44_c2_5 VSS VSS) nmos w=1u l=100n
M44_S2_5_X2_iv_P0 (x_or_M44_S2_5_x2 x_nor_M44_S2_5_x2 VDD VDD) pmos w=2u l=100n
M44_S2_5_X2_iv_N0 (x_or_M44_S2_5_x2 x_nor_M44_S2_5_x2 VSS VSS) nmos w=1u l=100n
M44_S2_5_X2_nd_PA0 (x_nand_M44_S2_5_x2 M44_S2_5_xab VDD VDD) pmos w=2u l=100n
M44_S2_5_X2_nd_PB0 (x_nand_M44_S2_5_x2 m44_c2_5 VDD VDD) pmos w=2u l=100n
M44_S2_5_X2_nd_NB0 (x_nand_M44_S2_5_x2 m44_c2_5 nmid_M44_S2_5_X2_nd_0 VSS) nmos w=1u l=100n
M44_S2_5_X2_nd_NA0 (nmid_M44_S2_5_X2_nd_0 M44_S2_5_xab VSS VSS) nmos w=1u l=100n
M44_S2_5_X2_na_PA0 (x_pre_M44_S2_5_x2 x_or_M44_S2_5_x2 VDD VDD) pmos w=2u l=100n
M44_S2_5_X2_na_PB0 (x_pre_M44_S2_5_x2 x_nand_M44_S2_5_x2 VDD VDD) pmos w=2u l=100n
M44_S2_5_X2_na_NB0 (x_pre_M44_S2_5_x2 x_nand_M44_S2_5_x2 nmid_M44_S2_5_X2_na_0 VSS) nmos w=1u l=100n
M44_S2_5_X2_na_NA0 (nmid_M44_S2_5_X2_na_0 x_or_M44_S2_5_x2 VSS VSS) nmos w=1u l=100n
M44_S2_5_X2_xo_P0 (m44_s2_5 x_pre_M44_S2_5_x2 VDD VDD) pmos w=2u l=100n
M44_S2_5_X2_xo_N0 (m44_s2_5 x_pre_M44_S2_5_x2 VSS VSS) nmos w=1u l=100n
M44_S2_5_AB_N_PA0 (M44_S2_5_ab_n m44_s1_5 VDD VDD) pmos w=2u l=100n
M44_S2_5_AB_N_PB0 (M44_S2_5_ab_n m44_pp32 VDD VDD) pmos w=2u l=100n
M44_S2_5_AB_N_NB0 (M44_S2_5_ab_n m44_pp32 nmid_M44_S2_5_AB_N_0 VSS) nmos w=1u l=100n
M44_S2_5_AB_N_NA0 (nmid_M44_S2_5_AB_N_0 m44_s1_5 VSS VSS) nmos w=1u l=100n
M44_S2_5_AB_I_P0 (M44_S2_5_ab M44_S2_5_ab_n VDD VDD) pmos w=2u l=100n
M44_S2_5_AB_I_N0 (M44_S2_5_ab M44_S2_5_ab_n VSS VSS) nmos w=1u l=100n
M44_S2_5_XC_N_PA0 (M44_S2_5_xc_n M44_S2_5_xab VDD VDD) pmos w=2u l=100n
M44_S2_5_XC_N_PB0 (M44_S2_5_xc_n m44_c2_5 VDD VDD) pmos w=2u l=100n
M44_S2_5_XC_N_NB0 (M44_S2_5_xc_n m44_c2_5 nmid_M44_S2_5_XC_N_0 VSS) nmos w=1u l=100n
M44_S2_5_XC_N_NA0 (nmid_M44_S2_5_XC_N_0 M44_S2_5_xab VSS VSS) nmos w=1u l=100n
M44_S2_5_XC_I_P0 (M44_S2_5_xc M44_S2_5_xc_n VDD VDD) pmos w=2u l=100n
M44_S2_5_XC_I_N0 (M44_S2_5_xc M44_S2_5_xc_n VSS VSS) nmos w=1u l=100n
M44_S2_5_OR_N_PA0 (pmid_M44_S2_5_OR_N_0 M44_S2_5_ab VDD VDD) pmos w=2u l=100n
M44_S2_5_OR_N_PB0 (m44_c2_6_n M44_S2_5_xc pmid_M44_S2_5_OR_N_0 VDD) pmos w=2u l=100n
M44_S2_5_OR_N_NA0 (m44_c2_6_n M44_S2_5_ab VSS VSS) nmos w=1u l=100n
M44_S2_5_OR_N_NB0 (m44_c2_6_n M44_S2_5_xc VSS VSS) nmos w=1u l=100n
M44_S2_5_OR_I_P0 (m44_c2_6 m44_c2_6_n VDD VDD) pmos w=2u l=100n
M44_S2_5_OR_I_N0 (m44_c2_6 m44_c2_6_n VSS VSS) nmos w=1u l=100n
M44_S2_6_X1_nr_PA0 (pmid_M44_S2_6_X1_nr_0 m44_s1_6 VDD VDD) pmos w=2u l=100n
M44_S2_6_X1_nr_PB0 (x_nor_M44_S2_6_x1 VSS pmid_M44_S2_6_X1_nr_0 VDD) pmos w=2u l=100n
M44_S2_6_X1_nr_NA0 (x_nor_M44_S2_6_x1 m44_s1_6 VSS VSS) nmos w=1u l=100n
M44_S2_6_X1_nr_NB0 (x_nor_M44_S2_6_x1 VSS VSS VSS) nmos w=1u l=100n
M44_S2_6_X1_iv_P0 (x_or_M44_S2_6_x1 x_nor_M44_S2_6_x1 VDD VDD) pmos w=2u l=100n
M44_S2_6_X1_iv_N0 (x_or_M44_S2_6_x1 x_nor_M44_S2_6_x1 VSS VSS) nmos w=1u l=100n
M44_S2_6_X1_nd_PA0 (x_nand_M44_S2_6_x1 m44_s1_6 VDD VDD) pmos w=2u l=100n
M44_S2_6_X1_nd_PB0 (x_nand_M44_S2_6_x1 VSS VDD VDD) pmos w=2u l=100n
M44_S2_6_X1_nd_NB0 (x_nand_M44_S2_6_x1 VSS nmid_M44_S2_6_X1_nd_0 VSS) nmos w=1u l=100n
M44_S2_6_X1_nd_NA0 (nmid_M44_S2_6_X1_nd_0 m44_s1_6 VSS VSS) nmos w=1u l=100n
M44_S2_6_X1_na_PA0 (x_pre_M44_S2_6_x1 x_or_M44_S2_6_x1 VDD VDD) pmos w=2u l=100n
M44_S2_6_X1_na_PB0 (x_pre_M44_S2_6_x1 x_nand_M44_S2_6_x1 VDD VDD) pmos w=2u l=100n
M44_S2_6_X1_na_NB0 (x_pre_M44_S2_6_x1 x_nand_M44_S2_6_x1 nmid_M44_S2_6_X1_na_0 VSS) nmos w=1u l=100n
M44_S2_6_X1_na_NA0 (nmid_M44_S2_6_X1_na_0 x_or_M44_S2_6_x1 VSS VSS) nmos w=1u l=100n
M44_S2_6_X1_xo_P0 (M44_S2_6_xab x_pre_M44_S2_6_x1 VDD VDD) pmos w=2u l=100n
M44_S2_6_X1_xo_N0 (M44_S2_6_xab x_pre_M44_S2_6_x1 VSS VSS) nmos w=1u l=100n
M44_S2_6_X2_nr_PA0 (pmid_M44_S2_6_X2_nr_0 M44_S2_6_xab VDD VDD) pmos w=2u l=100n
M44_S2_6_X2_nr_PB0 (x_nor_M44_S2_6_x2 m44_c2_6 pmid_M44_S2_6_X2_nr_0 VDD) pmos w=2u l=100n
M44_S2_6_X2_nr_NA0 (x_nor_M44_S2_6_x2 M44_S2_6_xab VSS VSS) nmos w=1u l=100n
M44_S2_6_X2_nr_NB0 (x_nor_M44_S2_6_x2 m44_c2_6 VSS VSS) nmos w=1u l=100n
M44_S2_6_X2_iv_P0 (x_or_M44_S2_6_x2 x_nor_M44_S2_6_x2 VDD VDD) pmos w=2u l=100n
M44_S2_6_X2_iv_N0 (x_or_M44_S2_6_x2 x_nor_M44_S2_6_x2 VSS VSS) nmos w=1u l=100n
M44_S2_6_X2_nd_PA0 (x_nand_M44_S2_6_x2 M44_S2_6_xab VDD VDD) pmos w=2u l=100n
M44_S2_6_X2_nd_PB0 (x_nand_M44_S2_6_x2 m44_c2_6 VDD VDD) pmos w=2u l=100n
M44_S2_6_X2_nd_NB0 (x_nand_M44_S2_6_x2 m44_c2_6 nmid_M44_S2_6_X2_nd_0 VSS) nmos w=1u l=100n
M44_S2_6_X2_nd_NA0 (nmid_M44_S2_6_X2_nd_0 M44_S2_6_xab VSS VSS) nmos w=1u l=100n
M44_S2_6_X2_na_PA0 (x_pre_M44_S2_6_x2 x_or_M44_S2_6_x2 VDD VDD) pmos w=2u l=100n
M44_S2_6_X2_na_PB0 (x_pre_M44_S2_6_x2 x_nand_M44_S2_6_x2 VDD VDD) pmos w=2u l=100n
M44_S2_6_X2_na_NB0 (x_pre_M44_S2_6_x2 x_nand_M44_S2_6_x2 nmid_M44_S2_6_X2_na_0 VSS) nmos w=1u l=100n
M44_S2_6_X2_na_NA0 (nmid_M44_S2_6_X2_na_0 x_or_M44_S2_6_x2 VSS VSS) nmos w=1u l=100n
M44_S2_6_X2_xo_P0 (m44_s2_6 x_pre_M44_S2_6_x2 VDD VDD) pmos w=2u l=100n
M44_S2_6_X2_xo_N0 (m44_s2_6 x_pre_M44_S2_6_x2 VSS VSS) nmos w=1u l=100n
M44_S2_6_AB_N_PA0 (M44_S2_6_ab_n m44_s1_6 VDD VDD) pmos w=2u l=100n
M44_S2_6_AB_N_PB0 (M44_S2_6_ab_n VSS VDD VDD) pmos w=2u l=100n
M44_S2_6_AB_N_NB0 (M44_S2_6_ab_n VSS nmid_M44_S2_6_AB_N_0 VSS) nmos w=1u l=100n
M44_S2_6_AB_N_NA0 (nmid_M44_S2_6_AB_N_0 m44_s1_6 VSS VSS) nmos w=1u l=100n
M44_S2_6_AB_I_P0 (M44_S2_6_ab M44_S2_6_ab_n VDD VDD) pmos w=2u l=100n
M44_S2_6_AB_I_N0 (M44_S2_6_ab M44_S2_6_ab_n VSS VSS) nmos w=1u l=100n
M44_S2_6_XC_N_PA0 (M44_S2_6_xc_n M44_S2_6_xab VDD VDD) pmos w=2u l=100n
M44_S2_6_XC_N_PB0 (M44_S2_6_xc_n m44_c2_6 VDD VDD) pmos w=2u l=100n
M44_S2_6_XC_N_NB0 (M44_S2_6_xc_n m44_c2_6 nmid_M44_S2_6_XC_N_0 VSS) nmos w=1u l=100n
M44_S2_6_XC_N_NA0 (nmid_M44_S2_6_XC_N_0 M44_S2_6_xab VSS VSS) nmos w=1u l=100n
M44_S2_6_XC_I_P0 (M44_S2_6_xc M44_S2_6_xc_n VDD VDD) pmos w=2u l=100n
M44_S2_6_XC_I_N0 (M44_S2_6_xc M44_S2_6_xc_n VSS VSS) nmos w=1u l=100n
M44_S2_6_OR_N_PA0 (pmid_M44_S2_6_OR_N_0 M44_S2_6_ab VDD VDD) pmos w=2u l=100n
M44_S2_6_OR_N_PB0 (m44_c2_7_n M44_S2_6_xc pmid_M44_S2_6_OR_N_0 VDD) pmos w=2u l=100n
M44_S2_6_OR_N_NA0 (m44_c2_7_n M44_S2_6_ab VSS VSS) nmos w=1u l=100n
M44_S2_6_OR_N_NB0 (m44_c2_7_n M44_S2_6_xc VSS VSS) nmos w=1u l=100n
M44_S2_6_OR_I_P0 (m44_c2_7 m44_c2_7_n VDD VDD) pmos w=2u l=100n
M44_S2_6_OR_I_N0 (m44_c2_7 m44_c2_7_n VSS VSS) nmos w=1u l=100n
M44_S2_7_X1_nr_PA0 (pmid_M44_S2_7_X1_nr_0 m44_s1_7 VDD VDD) pmos w=2u l=100n
M44_S2_7_X1_nr_PB0 (x_nor_M44_S2_7_x1 VSS pmid_M44_S2_7_X1_nr_0 VDD) pmos w=2u l=100n
M44_S2_7_X1_nr_NA0 (x_nor_M44_S2_7_x1 m44_s1_7 VSS VSS) nmos w=1u l=100n
M44_S2_7_X1_nr_NB0 (x_nor_M44_S2_7_x1 VSS VSS VSS) nmos w=1u l=100n
M44_S2_7_X1_iv_P0 (x_or_M44_S2_7_x1 x_nor_M44_S2_7_x1 VDD VDD) pmos w=2u l=100n
M44_S2_7_X1_iv_N0 (x_or_M44_S2_7_x1 x_nor_M44_S2_7_x1 VSS VSS) nmos w=1u l=100n
M44_S2_7_X1_nd_PA0 (x_nand_M44_S2_7_x1 m44_s1_7 VDD VDD) pmos w=2u l=100n
M44_S2_7_X1_nd_PB0 (x_nand_M44_S2_7_x1 VSS VDD VDD) pmos w=2u l=100n
M44_S2_7_X1_nd_NB0 (x_nand_M44_S2_7_x1 VSS nmid_M44_S2_7_X1_nd_0 VSS) nmos w=1u l=100n
M44_S2_7_X1_nd_NA0 (nmid_M44_S2_7_X1_nd_0 m44_s1_7 VSS VSS) nmos w=1u l=100n
M44_S2_7_X1_na_PA0 (x_pre_M44_S2_7_x1 x_or_M44_S2_7_x1 VDD VDD) pmos w=2u l=100n
M44_S2_7_X1_na_PB0 (x_pre_M44_S2_7_x1 x_nand_M44_S2_7_x1 VDD VDD) pmos w=2u l=100n
M44_S2_7_X1_na_NB0 (x_pre_M44_S2_7_x1 x_nand_M44_S2_7_x1 nmid_M44_S2_7_X1_na_0 VSS) nmos w=1u l=100n
M44_S2_7_X1_na_NA0 (nmid_M44_S2_7_X1_na_0 x_or_M44_S2_7_x1 VSS VSS) nmos w=1u l=100n
M44_S2_7_X1_xo_P0 (M44_S2_7_xab x_pre_M44_S2_7_x1 VDD VDD) pmos w=2u l=100n
M44_S2_7_X1_xo_N0 (M44_S2_7_xab x_pre_M44_S2_7_x1 VSS VSS) nmos w=1u l=100n
M44_S2_7_X2_nr_PA0 (pmid_M44_S2_7_X2_nr_0 M44_S2_7_xab VDD VDD) pmos w=2u l=100n
M44_S2_7_X2_nr_PB0 (x_nor_M44_S2_7_x2 m44_c2_7 pmid_M44_S2_7_X2_nr_0 VDD) pmos w=2u l=100n
M44_S2_7_X2_nr_NA0 (x_nor_M44_S2_7_x2 M44_S2_7_xab VSS VSS) nmos w=1u l=100n
M44_S2_7_X2_nr_NB0 (x_nor_M44_S2_7_x2 m44_c2_7 VSS VSS) nmos w=1u l=100n
M44_S2_7_X2_iv_P0 (x_or_M44_S2_7_x2 x_nor_M44_S2_7_x2 VDD VDD) pmos w=2u l=100n
M44_S2_7_X2_iv_N0 (x_or_M44_S2_7_x2 x_nor_M44_S2_7_x2 VSS VSS) nmos w=1u l=100n
M44_S2_7_X2_nd_PA0 (x_nand_M44_S2_7_x2 M44_S2_7_xab VDD VDD) pmos w=2u l=100n
M44_S2_7_X2_nd_PB0 (x_nand_M44_S2_7_x2 m44_c2_7 VDD VDD) pmos w=2u l=100n
M44_S2_7_X2_nd_NB0 (x_nand_M44_S2_7_x2 m44_c2_7 nmid_M44_S2_7_X2_nd_0 VSS) nmos w=1u l=100n
M44_S2_7_X2_nd_NA0 (nmid_M44_S2_7_X2_nd_0 M44_S2_7_xab VSS VSS) nmos w=1u l=100n
M44_S2_7_X2_na_PA0 (x_pre_M44_S2_7_x2 x_or_M44_S2_7_x2 VDD VDD) pmos w=2u l=100n
M44_S2_7_X2_na_PB0 (x_pre_M44_S2_7_x2 x_nand_M44_S2_7_x2 VDD VDD) pmos w=2u l=100n
M44_S2_7_X2_na_NB0 (x_pre_M44_S2_7_x2 x_nand_M44_S2_7_x2 nmid_M44_S2_7_X2_na_0 VSS) nmos w=1u l=100n
M44_S2_7_X2_na_NA0 (nmid_M44_S2_7_X2_na_0 x_or_M44_S2_7_x2 VSS VSS) nmos w=1u l=100n
M44_S2_7_X2_xo_P0 (m44_s2_7 x_pre_M44_S2_7_x2 VDD VDD) pmos w=2u l=100n
M44_S2_7_X2_xo_N0 (m44_s2_7 x_pre_M44_S2_7_x2 VSS VSS) nmos w=1u l=100n
M44_S2_7_AB_N_PA0 (M44_S2_7_ab_n m44_s1_7 VDD VDD) pmos w=2u l=100n
M44_S2_7_AB_N_PB0 (M44_S2_7_ab_n VSS VDD VDD) pmos w=2u l=100n
M44_S2_7_AB_N_NB0 (M44_S2_7_ab_n VSS nmid_M44_S2_7_AB_N_0 VSS) nmos w=1u l=100n
M44_S2_7_AB_N_NA0 (nmid_M44_S2_7_AB_N_0 m44_s1_7 VSS VSS) nmos w=1u l=100n
M44_S2_7_AB_I_P0 (M44_S2_7_ab M44_S2_7_ab_n VDD VDD) pmos w=2u l=100n
M44_S2_7_AB_I_N0 (M44_S2_7_ab M44_S2_7_ab_n VSS VSS) nmos w=1u l=100n
M44_S2_7_XC_N_PA0 (M44_S2_7_xc_n M44_S2_7_xab VDD VDD) pmos w=2u l=100n
M44_S2_7_XC_N_PB0 (M44_S2_7_xc_n m44_c2_7 VDD VDD) pmos w=2u l=100n
M44_S2_7_XC_N_NB0 (M44_S2_7_xc_n m44_c2_7 nmid_M44_S2_7_XC_N_0 VSS) nmos w=1u l=100n
M44_S2_7_XC_N_NA0 (nmid_M44_S2_7_XC_N_0 M44_S2_7_xab VSS VSS) nmos w=1u l=100n
M44_S2_7_XC_I_P0 (M44_S2_7_xc M44_S2_7_xc_n VDD VDD) pmos w=2u l=100n
M44_S2_7_XC_I_N0 (M44_S2_7_xc M44_S2_7_xc_n VSS VSS) nmos w=1u l=100n
M44_S2_7_OR_N_PA0 (pmid_M44_S2_7_OR_N_0 M44_S2_7_ab VDD VDD) pmos w=2u l=100n
M44_S2_7_OR_N_PB0 (m44_c2_8_n M44_S2_7_xc pmid_M44_S2_7_OR_N_0 VDD) pmos w=2u l=100n
M44_S2_7_OR_N_NA0 (m44_c2_8_n M44_S2_7_ab VSS VSS) nmos w=1u l=100n
M44_S2_7_OR_N_NB0 (m44_c2_8_n M44_S2_7_xc VSS VSS) nmos w=1u l=100n
M44_S2_7_OR_I_P0 (m44_c2_8 m44_c2_8_n VDD VDD) pmos w=2u l=100n
M44_S2_7_OR_I_N0 (m44_c2_8 m44_c2_8_n VSS VSS) nmos w=1u l=100n
M44_S30_nr_PA0 (pmid_M44_S30_nr_0 m44_s2_0 VDD VDD) pmos w=2u l=100n
M44_S30_nr_PB0 (x_nor_m44s30 VSS pmid_M44_S30_nr_0 VDD) pmos w=2u l=100n
M44_S30_nr_NA0 (x_nor_m44s30 m44_s2_0 VSS VSS) nmos w=1u l=100n
M44_S30_nr_NB0 (x_nor_m44s30 VSS VSS VSS) nmos w=1u l=100n
M44_S30_iv_P0 (x_or_m44s30 x_nor_m44s30 VDD VDD) pmos w=2u l=100n
M44_S30_iv_N0 (x_or_m44s30 x_nor_m44s30 VSS VSS) nmos w=1u l=100n
M44_S30_nd_PA0 (x_nand_m44s30 m44_s2_0 VDD VDD) pmos w=2u l=100n
M44_S30_nd_PB0 (x_nand_m44s30 VSS VDD VDD) pmos w=2u l=100n
M44_S30_nd_NB0 (x_nand_m44s30 VSS nmid_M44_S30_nd_0 VSS) nmos w=1u l=100n
M44_S30_nd_NA0 (nmid_M44_S30_nd_0 m44_s2_0 VSS VSS) nmos w=1u l=100n
M44_S30_na_PA0 (x_pre_m44s30 x_or_m44s30 VDD VDD) pmos w=2u l=100n
M44_S30_na_PB0 (x_pre_m44s30 x_nand_m44s30 VDD VDD) pmos w=2u l=100n
M44_S30_na_NB0 (x_pre_m44s30 x_nand_m44s30 nmid_M44_S30_na_0 VSS) nmos w=1u l=100n
M44_S30_na_NA0 (nmid_M44_S30_na_0 x_or_m44s30 VSS VSS) nmos w=1u l=100n
M44_S30_xo_P0 (P0 x_pre_m44s30 VDD VDD) pmos w=2u l=100n
M44_S30_xo_N0 (P0 x_pre_m44s30 VSS VSS) nmos w=1u l=100n
M44_C31_N_PA0 (m44_c3_1_n m44_s2_0 VDD VDD) pmos w=2u l=100n
M44_C31_N_PB0 (m44_c3_1_n VSS VDD VDD) pmos w=2u l=100n
M44_C31_N_NB0 (m44_c3_1_n VSS nmid_M44_C31_N_0 VSS) nmos w=1u l=100n
M44_C31_N_NA0 (nmid_M44_C31_N_0 m44_s2_0 VSS VSS) nmos w=1u l=100n
M44_C31_I_P0 (m44_c3_1 m44_c3_1_n VDD VDD) pmos w=2u l=100n
M44_C31_I_N0 (m44_c3_1 m44_c3_1_n VSS VSS) nmos w=1u l=100n
M44_S3_1_X1_nr_PA0 (pmid_M44_S3_1_X1_nr_0 m44_s2_1 VDD VDD) pmos w=2u l=100n
M44_S3_1_X1_nr_PB0 (x_nor_M44_S3_1_x1 VSS pmid_M44_S3_1_X1_nr_0 VDD) pmos w=2u l=100n
M44_S3_1_X1_nr_NA0 (x_nor_M44_S3_1_x1 m44_s2_1 VSS VSS) nmos w=1u l=100n
M44_S3_1_X1_nr_NB0 (x_nor_M44_S3_1_x1 VSS VSS VSS) nmos w=1u l=100n
M44_S3_1_X1_iv_P0 (x_or_M44_S3_1_x1 x_nor_M44_S3_1_x1 VDD VDD) pmos w=2u l=100n
M44_S3_1_X1_iv_N0 (x_or_M44_S3_1_x1 x_nor_M44_S3_1_x1 VSS VSS) nmos w=1u l=100n
M44_S3_1_X1_nd_PA0 (x_nand_M44_S3_1_x1 m44_s2_1 VDD VDD) pmos w=2u l=100n
M44_S3_1_X1_nd_PB0 (x_nand_M44_S3_1_x1 VSS VDD VDD) pmos w=2u l=100n
M44_S3_1_X1_nd_NB0 (x_nand_M44_S3_1_x1 VSS nmid_M44_S3_1_X1_nd_0 VSS) nmos w=1u l=100n
M44_S3_1_X1_nd_NA0 (nmid_M44_S3_1_X1_nd_0 m44_s2_1 VSS VSS) nmos w=1u l=100n
M44_S3_1_X1_na_PA0 (x_pre_M44_S3_1_x1 x_or_M44_S3_1_x1 VDD VDD) pmos w=2u l=100n
M44_S3_1_X1_na_PB0 (x_pre_M44_S3_1_x1 x_nand_M44_S3_1_x1 VDD VDD) pmos w=2u l=100n
M44_S3_1_X1_na_NB0 (x_pre_M44_S3_1_x1 x_nand_M44_S3_1_x1 nmid_M44_S3_1_X1_na_0 VSS) nmos w=1u l=100n
M44_S3_1_X1_na_NA0 (nmid_M44_S3_1_X1_na_0 x_or_M44_S3_1_x1 VSS VSS) nmos w=1u l=100n
M44_S3_1_X1_xo_P0 (M44_S3_1_xab x_pre_M44_S3_1_x1 VDD VDD) pmos w=2u l=100n
M44_S3_1_X1_xo_N0 (M44_S3_1_xab x_pre_M44_S3_1_x1 VSS VSS) nmos w=1u l=100n
M44_S3_1_X2_nr_PA0 (pmid_M44_S3_1_X2_nr_0 M44_S3_1_xab VDD VDD) pmos w=2u l=100n
M44_S3_1_X2_nr_PB0 (x_nor_M44_S3_1_x2 m44_c3_1 pmid_M44_S3_1_X2_nr_0 VDD) pmos w=2u l=100n
M44_S3_1_X2_nr_NA0 (x_nor_M44_S3_1_x2 M44_S3_1_xab VSS VSS) nmos w=1u l=100n
M44_S3_1_X2_nr_NB0 (x_nor_M44_S3_1_x2 m44_c3_1 VSS VSS) nmos w=1u l=100n
M44_S3_1_X2_iv_P0 (x_or_M44_S3_1_x2 x_nor_M44_S3_1_x2 VDD VDD) pmos w=2u l=100n
M44_S3_1_X2_iv_N0 (x_or_M44_S3_1_x2 x_nor_M44_S3_1_x2 VSS VSS) nmos w=1u l=100n
M44_S3_1_X2_nd_PA0 (x_nand_M44_S3_1_x2 M44_S3_1_xab VDD VDD) pmos w=2u l=100n
M44_S3_1_X2_nd_PB0 (x_nand_M44_S3_1_x2 m44_c3_1 VDD VDD) pmos w=2u l=100n
M44_S3_1_X2_nd_NB0 (x_nand_M44_S3_1_x2 m44_c3_1 nmid_M44_S3_1_X2_nd_0 VSS) nmos w=1u l=100n
M44_S3_1_X2_nd_NA0 (nmid_M44_S3_1_X2_nd_0 M44_S3_1_xab VSS VSS) nmos w=1u l=100n
M44_S3_1_X2_na_PA0 (x_pre_M44_S3_1_x2 x_or_M44_S3_1_x2 VDD VDD) pmos w=2u l=100n
M44_S3_1_X2_na_PB0 (x_pre_M44_S3_1_x2 x_nand_M44_S3_1_x2 VDD VDD) pmos w=2u l=100n
M44_S3_1_X2_na_NB0 (x_pre_M44_S3_1_x2 x_nand_M44_S3_1_x2 nmid_M44_S3_1_X2_na_0 VSS) nmos w=1u l=100n
M44_S3_1_X2_na_NA0 (nmid_M44_S3_1_X2_na_0 x_or_M44_S3_1_x2 VSS VSS) nmos w=1u l=100n
M44_S3_1_X2_xo_P0 (P1 x_pre_M44_S3_1_x2 VDD VDD) pmos w=2u l=100n
M44_S3_1_X2_xo_N0 (P1 x_pre_M44_S3_1_x2 VSS VSS) nmos w=1u l=100n
M44_S3_1_AB_N_PA0 (M44_S3_1_ab_n m44_s2_1 VDD VDD) pmos w=2u l=100n
M44_S3_1_AB_N_PB0 (M44_S3_1_ab_n VSS VDD VDD) pmos w=2u l=100n
M44_S3_1_AB_N_NB0 (M44_S3_1_ab_n VSS nmid_M44_S3_1_AB_N_0 VSS) nmos w=1u l=100n
M44_S3_1_AB_N_NA0 (nmid_M44_S3_1_AB_N_0 m44_s2_1 VSS VSS) nmos w=1u l=100n
M44_S3_1_AB_I_P0 (M44_S3_1_ab M44_S3_1_ab_n VDD VDD) pmos w=2u l=100n
M44_S3_1_AB_I_N0 (M44_S3_1_ab M44_S3_1_ab_n VSS VSS) nmos w=1u l=100n
M44_S3_1_XC_N_PA0 (M44_S3_1_xc_n M44_S3_1_xab VDD VDD) pmos w=2u l=100n
M44_S3_1_XC_N_PB0 (M44_S3_1_xc_n m44_c3_1 VDD VDD) pmos w=2u l=100n
M44_S3_1_XC_N_NB0 (M44_S3_1_xc_n m44_c3_1 nmid_M44_S3_1_XC_N_0 VSS) nmos w=1u l=100n
M44_S3_1_XC_N_NA0 (nmid_M44_S3_1_XC_N_0 M44_S3_1_xab VSS VSS) nmos w=1u l=100n
M44_S3_1_XC_I_P0 (M44_S3_1_xc M44_S3_1_xc_n VDD VDD) pmos w=2u l=100n
M44_S3_1_XC_I_N0 (M44_S3_1_xc M44_S3_1_xc_n VSS VSS) nmos w=1u l=100n
M44_S3_1_OR_N_PA0 (pmid_M44_S3_1_OR_N_0 M44_S3_1_ab VDD VDD) pmos w=2u l=100n
M44_S3_1_OR_N_PB0 (m44_c3_2_n M44_S3_1_xc pmid_M44_S3_1_OR_N_0 VDD) pmos w=2u l=100n
M44_S3_1_OR_N_NA0 (m44_c3_2_n M44_S3_1_ab VSS VSS) nmos w=1u l=100n
M44_S3_1_OR_N_NB0 (m44_c3_2_n M44_S3_1_xc VSS VSS) nmos w=1u l=100n
M44_S3_1_OR_I_P0 (m44_c3_2 m44_c3_2_n VDD VDD) pmos w=2u l=100n
M44_S3_1_OR_I_N0 (m44_c3_2 m44_c3_2_n VSS VSS) nmos w=1u l=100n
M44_S3_2_X1_nr_PA0 (pmid_M44_S3_2_X1_nr_0 m44_s2_2 VDD VDD) pmos w=2u l=100n
M44_S3_2_X1_nr_PB0 (x_nor_M44_S3_2_x1 VSS pmid_M44_S3_2_X1_nr_0 VDD) pmos w=2u l=100n
M44_S3_2_X1_nr_NA0 (x_nor_M44_S3_2_x1 m44_s2_2 VSS VSS) nmos w=1u l=100n
M44_S3_2_X1_nr_NB0 (x_nor_M44_S3_2_x1 VSS VSS VSS) nmos w=1u l=100n
M44_S3_2_X1_iv_P0 (x_or_M44_S3_2_x1 x_nor_M44_S3_2_x1 VDD VDD) pmos w=2u l=100n
M44_S3_2_X1_iv_N0 (x_or_M44_S3_2_x1 x_nor_M44_S3_2_x1 VSS VSS) nmos w=1u l=100n
M44_S3_2_X1_nd_PA0 (x_nand_M44_S3_2_x1 m44_s2_2 VDD VDD) pmos w=2u l=100n
M44_S3_2_X1_nd_PB0 (x_nand_M44_S3_2_x1 VSS VDD VDD) pmos w=2u l=100n
M44_S3_2_X1_nd_NB0 (x_nand_M44_S3_2_x1 VSS nmid_M44_S3_2_X1_nd_0 VSS) nmos w=1u l=100n
M44_S3_2_X1_nd_NA0 (nmid_M44_S3_2_X1_nd_0 m44_s2_2 VSS VSS) nmos w=1u l=100n
M44_S3_2_X1_na_PA0 (x_pre_M44_S3_2_x1 x_or_M44_S3_2_x1 VDD VDD) pmos w=2u l=100n
M44_S3_2_X1_na_PB0 (x_pre_M44_S3_2_x1 x_nand_M44_S3_2_x1 VDD VDD) pmos w=2u l=100n
M44_S3_2_X1_na_NB0 (x_pre_M44_S3_2_x1 x_nand_M44_S3_2_x1 nmid_M44_S3_2_X1_na_0 VSS) nmos w=1u l=100n
M44_S3_2_X1_na_NA0 (nmid_M44_S3_2_X1_na_0 x_or_M44_S3_2_x1 VSS VSS) nmos w=1u l=100n
M44_S3_2_X1_xo_P0 (M44_S3_2_xab x_pre_M44_S3_2_x1 VDD VDD) pmos w=2u l=100n
M44_S3_2_X1_xo_N0 (M44_S3_2_xab x_pre_M44_S3_2_x1 VSS VSS) nmos w=1u l=100n
M44_S3_2_X2_nr_PA0 (pmid_M44_S3_2_X2_nr_0 M44_S3_2_xab VDD VDD) pmos w=2u l=100n
M44_S3_2_X2_nr_PB0 (x_nor_M44_S3_2_x2 m44_c3_2 pmid_M44_S3_2_X2_nr_0 VDD) pmos w=2u l=100n
M44_S3_2_X2_nr_NA0 (x_nor_M44_S3_2_x2 M44_S3_2_xab VSS VSS) nmos w=1u l=100n
M44_S3_2_X2_nr_NB0 (x_nor_M44_S3_2_x2 m44_c3_2 VSS VSS) nmos w=1u l=100n
M44_S3_2_X2_iv_P0 (x_or_M44_S3_2_x2 x_nor_M44_S3_2_x2 VDD VDD) pmos w=2u l=100n
M44_S3_2_X2_iv_N0 (x_or_M44_S3_2_x2 x_nor_M44_S3_2_x2 VSS VSS) nmos w=1u l=100n
M44_S3_2_X2_nd_PA0 (x_nand_M44_S3_2_x2 M44_S3_2_xab VDD VDD) pmos w=2u l=100n
M44_S3_2_X2_nd_PB0 (x_nand_M44_S3_2_x2 m44_c3_2 VDD VDD) pmos w=2u l=100n
M44_S3_2_X2_nd_NB0 (x_nand_M44_S3_2_x2 m44_c3_2 nmid_M44_S3_2_X2_nd_0 VSS) nmos w=1u l=100n
M44_S3_2_X2_nd_NA0 (nmid_M44_S3_2_X2_nd_0 M44_S3_2_xab VSS VSS) nmos w=1u l=100n
M44_S3_2_X2_na_PA0 (x_pre_M44_S3_2_x2 x_or_M44_S3_2_x2 VDD VDD) pmos w=2u l=100n
M44_S3_2_X2_na_PB0 (x_pre_M44_S3_2_x2 x_nand_M44_S3_2_x2 VDD VDD) pmos w=2u l=100n
M44_S3_2_X2_na_NB0 (x_pre_M44_S3_2_x2 x_nand_M44_S3_2_x2 nmid_M44_S3_2_X2_na_0 VSS) nmos w=1u l=100n
M44_S3_2_X2_na_NA0 (nmid_M44_S3_2_X2_na_0 x_or_M44_S3_2_x2 VSS VSS) nmos w=1u l=100n
M44_S3_2_X2_xo_P0 (P2 x_pre_M44_S3_2_x2 VDD VDD) pmos w=2u l=100n
M44_S3_2_X2_xo_N0 (P2 x_pre_M44_S3_2_x2 VSS VSS) nmos w=1u l=100n
M44_S3_2_AB_N_PA0 (M44_S3_2_ab_n m44_s2_2 VDD VDD) pmos w=2u l=100n
M44_S3_2_AB_N_PB0 (M44_S3_2_ab_n VSS VDD VDD) pmos w=2u l=100n
M44_S3_2_AB_N_NB0 (M44_S3_2_ab_n VSS nmid_M44_S3_2_AB_N_0 VSS) nmos w=1u l=100n
M44_S3_2_AB_N_NA0 (nmid_M44_S3_2_AB_N_0 m44_s2_2 VSS VSS) nmos w=1u l=100n
M44_S3_2_AB_I_P0 (M44_S3_2_ab M44_S3_2_ab_n VDD VDD) pmos w=2u l=100n
M44_S3_2_AB_I_N0 (M44_S3_2_ab M44_S3_2_ab_n VSS VSS) nmos w=1u l=100n
M44_S3_2_XC_N_PA0 (M44_S3_2_xc_n M44_S3_2_xab VDD VDD) pmos w=2u l=100n
M44_S3_2_XC_N_PB0 (M44_S3_2_xc_n m44_c3_2 VDD VDD) pmos w=2u l=100n
M44_S3_2_XC_N_NB0 (M44_S3_2_xc_n m44_c3_2 nmid_M44_S3_2_XC_N_0 VSS) nmos w=1u l=100n
M44_S3_2_XC_N_NA0 (nmid_M44_S3_2_XC_N_0 M44_S3_2_xab VSS VSS) nmos w=1u l=100n
M44_S3_2_XC_I_P0 (M44_S3_2_xc M44_S3_2_xc_n VDD VDD) pmos w=2u l=100n
M44_S3_2_XC_I_N0 (M44_S3_2_xc M44_S3_2_xc_n VSS VSS) nmos w=1u l=100n
M44_S3_2_OR_N_PA0 (pmid_M44_S3_2_OR_N_0 M44_S3_2_ab VDD VDD) pmos w=2u l=100n
M44_S3_2_OR_N_PB0 (m44_c3_3_n M44_S3_2_xc pmid_M44_S3_2_OR_N_0 VDD) pmos w=2u l=100n
M44_S3_2_OR_N_NA0 (m44_c3_3_n M44_S3_2_ab VSS VSS) nmos w=1u l=100n
M44_S3_2_OR_N_NB0 (m44_c3_3_n M44_S3_2_xc VSS VSS) nmos w=1u l=100n
M44_S3_2_OR_I_P0 (m44_c3_3 m44_c3_3_n VDD VDD) pmos w=2u l=100n
M44_S3_2_OR_I_N0 (m44_c3_3 m44_c3_3_n VSS VSS) nmos w=1u l=100n
M44_S3_3_X1_nr_PA0 (pmid_M44_S3_3_X1_nr_0 m44_s2_3 VDD VDD) pmos w=2u l=100n
M44_S3_3_X1_nr_PB0 (x_nor_M44_S3_3_x1 m44_pp03 pmid_M44_S3_3_X1_nr_0 VDD) pmos w=2u l=100n
M44_S3_3_X1_nr_NA0 (x_nor_M44_S3_3_x1 m44_s2_3 VSS VSS) nmos w=1u l=100n
M44_S3_3_X1_nr_NB0 (x_nor_M44_S3_3_x1 m44_pp03 VSS VSS) nmos w=1u l=100n
M44_S3_3_X1_iv_P0 (x_or_M44_S3_3_x1 x_nor_M44_S3_3_x1 VDD VDD) pmos w=2u l=100n
M44_S3_3_X1_iv_N0 (x_or_M44_S3_3_x1 x_nor_M44_S3_3_x1 VSS VSS) nmos w=1u l=100n
M44_S3_3_X1_nd_PA0 (x_nand_M44_S3_3_x1 m44_s2_3 VDD VDD) pmos w=2u l=100n
M44_S3_3_X1_nd_PB0 (x_nand_M44_S3_3_x1 m44_pp03 VDD VDD) pmos w=2u l=100n
M44_S3_3_X1_nd_NB0 (x_nand_M44_S3_3_x1 m44_pp03 nmid_M44_S3_3_X1_nd_0 VSS) nmos w=1u l=100n
M44_S3_3_X1_nd_NA0 (nmid_M44_S3_3_X1_nd_0 m44_s2_3 VSS VSS) nmos w=1u l=100n
M44_S3_3_X1_na_PA0 (x_pre_M44_S3_3_x1 x_or_M44_S3_3_x1 VDD VDD) pmos w=2u l=100n
M44_S3_3_X1_na_PB0 (x_pre_M44_S3_3_x1 x_nand_M44_S3_3_x1 VDD VDD) pmos w=2u l=100n
M44_S3_3_X1_na_NB0 (x_pre_M44_S3_3_x1 x_nand_M44_S3_3_x1 nmid_M44_S3_3_X1_na_0 VSS) nmos w=1u l=100n
M44_S3_3_X1_na_NA0 (nmid_M44_S3_3_X1_na_0 x_or_M44_S3_3_x1 VSS VSS) nmos w=1u l=100n
M44_S3_3_X1_xo_P0 (M44_S3_3_xab x_pre_M44_S3_3_x1 VDD VDD) pmos w=2u l=100n
M44_S3_3_X1_xo_N0 (M44_S3_3_xab x_pre_M44_S3_3_x1 VSS VSS) nmos w=1u l=100n
M44_S3_3_X2_nr_PA0 (pmid_M44_S3_3_X2_nr_0 M44_S3_3_xab VDD VDD) pmos w=2u l=100n
M44_S3_3_X2_nr_PB0 (x_nor_M44_S3_3_x2 m44_c3_3 pmid_M44_S3_3_X2_nr_0 VDD) pmos w=2u l=100n
M44_S3_3_X2_nr_NA0 (x_nor_M44_S3_3_x2 M44_S3_3_xab VSS VSS) nmos w=1u l=100n
M44_S3_3_X2_nr_NB0 (x_nor_M44_S3_3_x2 m44_c3_3 VSS VSS) nmos w=1u l=100n
M44_S3_3_X2_iv_P0 (x_or_M44_S3_3_x2 x_nor_M44_S3_3_x2 VDD VDD) pmos w=2u l=100n
M44_S3_3_X2_iv_N0 (x_or_M44_S3_3_x2 x_nor_M44_S3_3_x2 VSS VSS) nmos w=1u l=100n
M44_S3_3_X2_nd_PA0 (x_nand_M44_S3_3_x2 M44_S3_3_xab VDD VDD) pmos w=2u l=100n
M44_S3_3_X2_nd_PB0 (x_nand_M44_S3_3_x2 m44_c3_3 VDD VDD) pmos w=2u l=100n
M44_S3_3_X2_nd_NB0 (x_nand_M44_S3_3_x2 m44_c3_3 nmid_M44_S3_3_X2_nd_0 VSS) nmos w=1u l=100n
M44_S3_3_X2_nd_NA0 (nmid_M44_S3_3_X2_nd_0 M44_S3_3_xab VSS VSS) nmos w=1u l=100n
M44_S3_3_X2_na_PA0 (x_pre_M44_S3_3_x2 x_or_M44_S3_3_x2 VDD VDD) pmos w=2u l=100n
M44_S3_3_X2_na_PB0 (x_pre_M44_S3_3_x2 x_nand_M44_S3_3_x2 VDD VDD) pmos w=2u l=100n
M44_S3_3_X2_na_NB0 (x_pre_M44_S3_3_x2 x_nand_M44_S3_3_x2 nmid_M44_S3_3_X2_na_0 VSS) nmos w=1u l=100n
M44_S3_3_X2_na_NA0 (nmid_M44_S3_3_X2_na_0 x_or_M44_S3_3_x2 VSS VSS) nmos w=1u l=100n
M44_S3_3_X2_xo_P0 (P3 x_pre_M44_S3_3_x2 VDD VDD) pmos w=2u l=100n
M44_S3_3_X2_xo_N0 (P3 x_pre_M44_S3_3_x2 VSS VSS) nmos w=1u l=100n
M44_S3_3_AB_N_PA0 (M44_S3_3_ab_n m44_s2_3 VDD VDD) pmos w=2u l=100n
M44_S3_3_AB_N_PB0 (M44_S3_3_ab_n m44_pp03 VDD VDD) pmos w=2u l=100n
M44_S3_3_AB_N_NB0 (M44_S3_3_ab_n m44_pp03 nmid_M44_S3_3_AB_N_0 VSS) nmos w=1u l=100n
M44_S3_3_AB_N_NA0 (nmid_M44_S3_3_AB_N_0 m44_s2_3 VSS VSS) nmos w=1u l=100n
M44_S3_3_AB_I_P0 (M44_S3_3_ab M44_S3_3_ab_n VDD VDD) pmos w=2u l=100n
M44_S3_3_AB_I_N0 (M44_S3_3_ab M44_S3_3_ab_n VSS VSS) nmos w=1u l=100n
M44_S3_3_XC_N_PA0 (M44_S3_3_xc_n M44_S3_3_xab VDD VDD) pmos w=2u l=100n
M44_S3_3_XC_N_PB0 (M44_S3_3_xc_n m44_c3_3 VDD VDD) pmos w=2u l=100n
M44_S3_3_XC_N_NB0 (M44_S3_3_xc_n m44_c3_3 nmid_M44_S3_3_XC_N_0 VSS) nmos w=1u l=100n
M44_S3_3_XC_N_NA0 (nmid_M44_S3_3_XC_N_0 M44_S3_3_xab VSS VSS) nmos w=1u l=100n
M44_S3_3_XC_I_P0 (M44_S3_3_xc M44_S3_3_xc_n VDD VDD) pmos w=2u l=100n
M44_S3_3_XC_I_N0 (M44_S3_3_xc M44_S3_3_xc_n VSS VSS) nmos w=1u l=100n
M44_S3_3_OR_N_PA0 (pmid_M44_S3_3_OR_N_0 M44_S3_3_ab VDD VDD) pmos w=2u l=100n
M44_S3_3_OR_N_PB0 (m44_c3_4_n M44_S3_3_xc pmid_M44_S3_3_OR_N_0 VDD) pmos w=2u l=100n
M44_S3_3_OR_N_NA0 (m44_c3_4_n M44_S3_3_ab VSS VSS) nmos w=1u l=100n
M44_S3_3_OR_N_NB0 (m44_c3_4_n M44_S3_3_xc VSS VSS) nmos w=1u l=100n
M44_S3_3_OR_I_P0 (m44_c3_4 m44_c3_4_n VDD VDD) pmos w=2u l=100n
M44_S3_3_OR_I_N0 (m44_c3_4 m44_c3_4_n VSS VSS) nmos w=1u l=100n
M44_S3_4_X1_nr_PA0 (pmid_M44_S3_4_X1_nr_0 m44_s2_4 VDD VDD) pmos w=2u l=100n
M44_S3_4_X1_nr_PB0 (x_nor_M44_S3_4_x1 m44_pp13 pmid_M44_S3_4_X1_nr_0 VDD) pmos w=2u l=100n
M44_S3_4_X1_nr_NA0 (x_nor_M44_S3_4_x1 m44_s2_4 VSS VSS) nmos w=1u l=100n
M44_S3_4_X1_nr_NB0 (x_nor_M44_S3_4_x1 m44_pp13 VSS VSS) nmos w=1u l=100n
M44_S3_4_X1_iv_P0 (x_or_M44_S3_4_x1 x_nor_M44_S3_4_x1 VDD VDD) pmos w=2u l=100n
M44_S3_4_X1_iv_N0 (x_or_M44_S3_4_x1 x_nor_M44_S3_4_x1 VSS VSS) nmos w=1u l=100n
M44_S3_4_X1_nd_PA0 (x_nand_M44_S3_4_x1 m44_s2_4 VDD VDD) pmos w=2u l=100n
M44_S3_4_X1_nd_PB0 (x_nand_M44_S3_4_x1 m44_pp13 VDD VDD) pmos w=2u l=100n
M44_S3_4_X1_nd_NB0 (x_nand_M44_S3_4_x1 m44_pp13 nmid_M44_S3_4_X1_nd_0 VSS) nmos w=1u l=100n
M44_S3_4_X1_nd_NA0 (nmid_M44_S3_4_X1_nd_0 m44_s2_4 VSS VSS) nmos w=1u l=100n
M44_S3_4_X1_na_PA0 (x_pre_M44_S3_4_x1 x_or_M44_S3_4_x1 VDD VDD) pmos w=2u l=100n
M44_S3_4_X1_na_PB0 (x_pre_M44_S3_4_x1 x_nand_M44_S3_4_x1 VDD VDD) pmos w=2u l=100n
M44_S3_4_X1_na_NB0 (x_pre_M44_S3_4_x1 x_nand_M44_S3_4_x1 nmid_M44_S3_4_X1_na_0 VSS) nmos w=1u l=100n
M44_S3_4_X1_na_NA0 (nmid_M44_S3_4_X1_na_0 x_or_M44_S3_4_x1 VSS VSS) nmos w=1u l=100n
M44_S3_4_X1_xo_P0 (M44_S3_4_xab x_pre_M44_S3_4_x1 VDD VDD) pmos w=2u l=100n
M44_S3_4_X1_xo_N0 (M44_S3_4_xab x_pre_M44_S3_4_x1 VSS VSS) nmos w=1u l=100n
M44_S3_4_X2_nr_PA0 (pmid_M44_S3_4_X2_nr_0 M44_S3_4_xab VDD VDD) pmos w=2u l=100n
M44_S3_4_X2_nr_PB0 (x_nor_M44_S3_4_x2 m44_c3_4 pmid_M44_S3_4_X2_nr_0 VDD) pmos w=2u l=100n
M44_S3_4_X2_nr_NA0 (x_nor_M44_S3_4_x2 M44_S3_4_xab VSS VSS) nmos w=1u l=100n
M44_S3_4_X2_nr_NB0 (x_nor_M44_S3_4_x2 m44_c3_4 VSS VSS) nmos w=1u l=100n
M44_S3_4_X2_iv_P0 (x_or_M44_S3_4_x2 x_nor_M44_S3_4_x2 VDD VDD) pmos w=2u l=100n
M44_S3_4_X2_iv_N0 (x_or_M44_S3_4_x2 x_nor_M44_S3_4_x2 VSS VSS) nmos w=1u l=100n
M44_S3_4_X2_nd_PA0 (x_nand_M44_S3_4_x2 M44_S3_4_xab VDD VDD) pmos w=2u l=100n
M44_S3_4_X2_nd_PB0 (x_nand_M44_S3_4_x2 m44_c3_4 VDD VDD) pmos w=2u l=100n
M44_S3_4_X2_nd_NB0 (x_nand_M44_S3_4_x2 m44_c3_4 nmid_M44_S3_4_X2_nd_0 VSS) nmos w=1u l=100n
M44_S3_4_X2_nd_NA0 (nmid_M44_S3_4_X2_nd_0 M44_S3_4_xab VSS VSS) nmos w=1u l=100n
M44_S3_4_X2_na_PA0 (x_pre_M44_S3_4_x2 x_or_M44_S3_4_x2 VDD VDD) pmos w=2u l=100n
M44_S3_4_X2_na_PB0 (x_pre_M44_S3_4_x2 x_nand_M44_S3_4_x2 VDD VDD) pmos w=2u l=100n
M44_S3_4_X2_na_NB0 (x_pre_M44_S3_4_x2 x_nand_M44_S3_4_x2 nmid_M44_S3_4_X2_na_0 VSS) nmos w=1u l=100n
M44_S3_4_X2_na_NA0 (nmid_M44_S3_4_X2_na_0 x_or_M44_S3_4_x2 VSS VSS) nmos w=1u l=100n
M44_S3_4_X2_xo_P0 (P4 x_pre_M44_S3_4_x2 VDD VDD) pmos w=2u l=100n
M44_S3_4_X2_xo_N0 (P4 x_pre_M44_S3_4_x2 VSS VSS) nmos w=1u l=100n
M44_S3_4_AB_N_PA0 (M44_S3_4_ab_n m44_s2_4 VDD VDD) pmos w=2u l=100n
M44_S3_4_AB_N_PB0 (M44_S3_4_ab_n m44_pp13 VDD VDD) pmos w=2u l=100n
M44_S3_4_AB_N_NB0 (M44_S3_4_ab_n m44_pp13 nmid_M44_S3_4_AB_N_0 VSS) nmos w=1u l=100n
M44_S3_4_AB_N_NA0 (nmid_M44_S3_4_AB_N_0 m44_s2_4 VSS VSS) nmos w=1u l=100n
M44_S3_4_AB_I_P0 (M44_S3_4_ab M44_S3_4_ab_n VDD VDD) pmos w=2u l=100n
M44_S3_4_AB_I_N0 (M44_S3_4_ab M44_S3_4_ab_n VSS VSS) nmos w=1u l=100n
M44_S3_4_XC_N_PA0 (M44_S3_4_xc_n M44_S3_4_xab VDD VDD) pmos w=2u l=100n
M44_S3_4_XC_N_PB0 (M44_S3_4_xc_n m44_c3_4 VDD VDD) pmos w=2u l=100n
M44_S3_4_XC_N_NB0 (M44_S3_4_xc_n m44_c3_4 nmid_M44_S3_4_XC_N_0 VSS) nmos w=1u l=100n
M44_S3_4_XC_N_NA0 (nmid_M44_S3_4_XC_N_0 M44_S3_4_xab VSS VSS) nmos w=1u l=100n
M44_S3_4_XC_I_P0 (M44_S3_4_xc M44_S3_4_xc_n VDD VDD) pmos w=2u l=100n
M44_S3_4_XC_I_N0 (M44_S3_4_xc M44_S3_4_xc_n VSS VSS) nmos w=1u l=100n
M44_S3_4_OR_N_PA0 (pmid_M44_S3_4_OR_N_0 M44_S3_4_ab VDD VDD) pmos w=2u l=100n
M44_S3_4_OR_N_PB0 (m44_c3_5_n M44_S3_4_xc pmid_M44_S3_4_OR_N_0 VDD) pmos w=2u l=100n
M44_S3_4_OR_N_NA0 (m44_c3_5_n M44_S3_4_ab VSS VSS) nmos w=1u l=100n
M44_S3_4_OR_N_NB0 (m44_c3_5_n M44_S3_4_xc VSS VSS) nmos w=1u l=100n
M44_S3_4_OR_I_P0 (m44_c3_5 m44_c3_5_n VDD VDD) pmos w=2u l=100n
M44_S3_4_OR_I_N0 (m44_c3_5 m44_c3_5_n VSS VSS) nmos w=1u l=100n
M44_S3_5_X1_nr_PA0 (pmid_M44_S3_5_X1_nr_0 m44_s2_5 VDD VDD) pmos w=2u l=100n
M44_S3_5_X1_nr_PB0 (x_nor_M44_S3_5_x1 m44_pp23 pmid_M44_S3_5_X1_nr_0 VDD) pmos w=2u l=100n
M44_S3_5_X1_nr_NA0 (x_nor_M44_S3_5_x1 m44_s2_5 VSS VSS) nmos w=1u l=100n
M44_S3_5_X1_nr_NB0 (x_nor_M44_S3_5_x1 m44_pp23 VSS VSS) nmos w=1u l=100n
M44_S3_5_X1_iv_P0 (x_or_M44_S3_5_x1 x_nor_M44_S3_5_x1 VDD VDD) pmos w=2u l=100n
M44_S3_5_X1_iv_N0 (x_or_M44_S3_5_x1 x_nor_M44_S3_5_x1 VSS VSS) nmos w=1u l=100n
M44_S3_5_X1_nd_PA0 (x_nand_M44_S3_5_x1 m44_s2_5 VDD VDD) pmos w=2u l=100n
M44_S3_5_X1_nd_PB0 (x_nand_M44_S3_5_x1 m44_pp23 VDD VDD) pmos w=2u l=100n
M44_S3_5_X1_nd_NB0 (x_nand_M44_S3_5_x1 m44_pp23 nmid_M44_S3_5_X1_nd_0 VSS) nmos w=1u l=100n
M44_S3_5_X1_nd_NA0 (nmid_M44_S3_5_X1_nd_0 m44_s2_5 VSS VSS) nmos w=1u l=100n
M44_S3_5_X1_na_PA0 (x_pre_M44_S3_5_x1 x_or_M44_S3_5_x1 VDD VDD) pmos w=2u l=100n
M44_S3_5_X1_na_PB0 (x_pre_M44_S3_5_x1 x_nand_M44_S3_5_x1 VDD VDD) pmos w=2u l=100n
M44_S3_5_X1_na_NB0 (x_pre_M44_S3_5_x1 x_nand_M44_S3_5_x1 nmid_M44_S3_5_X1_na_0 VSS) nmos w=1u l=100n
M44_S3_5_X1_na_NA0 (nmid_M44_S3_5_X1_na_0 x_or_M44_S3_5_x1 VSS VSS) nmos w=1u l=100n
M44_S3_5_X1_xo_P0 (M44_S3_5_xab x_pre_M44_S3_5_x1 VDD VDD) pmos w=2u l=100n
M44_S3_5_X1_xo_N0 (M44_S3_5_xab x_pre_M44_S3_5_x1 VSS VSS) nmos w=1u l=100n
M44_S3_5_X2_nr_PA0 (pmid_M44_S3_5_X2_nr_0 M44_S3_5_xab VDD VDD) pmos w=2u l=100n
M44_S3_5_X2_nr_PB0 (x_nor_M44_S3_5_x2 m44_c3_5 pmid_M44_S3_5_X2_nr_0 VDD) pmos w=2u l=100n
M44_S3_5_X2_nr_NA0 (x_nor_M44_S3_5_x2 M44_S3_5_xab VSS VSS) nmos w=1u l=100n
M44_S3_5_X2_nr_NB0 (x_nor_M44_S3_5_x2 m44_c3_5 VSS VSS) nmos w=1u l=100n
M44_S3_5_X2_iv_P0 (x_or_M44_S3_5_x2 x_nor_M44_S3_5_x2 VDD VDD) pmos w=2u l=100n
M44_S3_5_X2_iv_N0 (x_or_M44_S3_5_x2 x_nor_M44_S3_5_x2 VSS VSS) nmos w=1u l=100n
M44_S3_5_X2_nd_PA0 (x_nand_M44_S3_5_x2 M44_S3_5_xab VDD VDD) pmos w=2u l=100n
M44_S3_5_X2_nd_PB0 (x_nand_M44_S3_5_x2 m44_c3_5 VDD VDD) pmos w=2u l=100n
M44_S3_5_X2_nd_NB0 (x_nand_M44_S3_5_x2 m44_c3_5 nmid_M44_S3_5_X2_nd_0 VSS) nmos w=1u l=100n
M44_S3_5_X2_nd_NA0 (nmid_M44_S3_5_X2_nd_0 M44_S3_5_xab VSS VSS) nmos w=1u l=100n
M44_S3_5_X2_na_PA0 (x_pre_M44_S3_5_x2 x_or_M44_S3_5_x2 VDD VDD) pmos w=2u l=100n
M44_S3_5_X2_na_PB0 (x_pre_M44_S3_5_x2 x_nand_M44_S3_5_x2 VDD VDD) pmos w=2u l=100n
M44_S3_5_X2_na_NB0 (x_pre_M44_S3_5_x2 x_nand_M44_S3_5_x2 nmid_M44_S3_5_X2_na_0 VSS) nmos w=1u l=100n
M44_S3_5_X2_na_NA0 (nmid_M44_S3_5_X2_na_0 x_or_M44_S3_5_x2 VSS VSS) nmos w=1u l=100n
M44_S3_5_X2_xo_P0 (P5 x_pre_M44_S3_5_x2 VDD VDD) pmos w=2u l=100n
M44_S3_5_X2_xo_N0 (P5 x_pre_M44_S3_5_x2 VSS VSS) nmos w=1u l=100n
M44_S3_5_AB_N_PA0 (M44_S3_5_ab_n m44_s2_5 VDD VDD) pmos w=2u l=100n
M44_S3_5_AB_N_PB0 (M44_S3_5_ab_n m44_pp23 VDD VDD) pmos w=2u l=100n
M44_S3_5_AB_N_NB0 (M44_S3_5_ab_n m44_pp23 nmid_M44_S3_5_AB_N_0 VSS) nmos w=1u l=100n
M44_S3_5_AB_N_NA0 (nmid_M44_S3_5_AB_N_0 m44_s2_5 VSS VSS) nmos w=1u l=100n
M44_S3_5_AB_I_P0 (M44_S3_5_ab M44_S3_5_ab_n VDD VDD) pmos w=2u l=100n
M44_S3_5_AB_I_N0 (M44_S3_5_ab M44_S3_5_ab_n VSS VSS) nmos w=1u l=100n
M44_S3_5_XC_N_PA0 (M44_S3_5_xc_n M44_S3_5_xab VDD VDD) pmos w=2u l=100n
M44_S3_5_XC_N_PB0 (M44_S3_5_xc_n m44_c3_5 VDD VDD) pmos w=2u l=100n
M44_S3_5_XC_N_NB0 (M44_S3_5_xc_n m44_c3_5 nmid_M44_S3_5_XC_N_0 VSS) nmos w=1u l=100n
M44_S3_5_XC_N_NA0 (nmid_M44_S3_5_XC_N_0 M44_S3_5_xab VSS VSS) nmos w=1u l=100n
M44_S3_5_XC_I_P0 (M44_S3_5_xc M44_S3_5_xc_n VDD VDD) pmos w=2u l=100n
M44_S3_5_XC_I_N0 (M44_S3_5_xc M44_S3_5_xc_n VSS VSS) nmos w=1u l=100n
M44_S3_5_OR_N_PA0 (pmid_M44_S3_5_OR_N_0 M44_S3_5_ab VDD VDD) pmos w=2u l=100n
M44_S3_5_OR_N_PB0 (m44_c3_6_n M44_S3_5_xc pmid_M44_S3_5_OR_N_0 VDD) pmos w=2u l=100n
M44_S3_5_OR_N_NA0 (m44_c3_6_n M44_S3_5_ab VSS VSS) nmos w=1u l=100n
M44_S3_5_OR_N_NB0 (m44_c3_6_n M44_S3_5_xc VSS VSS) nmos w=1u l=100n
M44_S3_5_OR_I_P0 (m44_c3_6 m44_c3_6_n VDD VDD) pmos w=2u l=100n
M44_S3_5_OR_I_N0 (m44_c3_6 m44_c3_6_n VSS VSS) nmos w=1u l=100n
M44_S3_6_X1_nr_PA0 (pmid_M44_S3_6_X1_nr_0 m44_s2_6 VDD VDD) pmos w=2u l=100n
M44_S3_6_X1_nr_PB0 (x_nor_M44_S3_6_x1 m44_pp33 pmid_M44_S3_6_X1_nr_0 VDD) pmos w=2u l=100n
M44_S3_6_X1_nr_NA0 (x_nor_M44_S3_6_x1 m44_s2_6 VSS VSS) nmos w=1u l=100n
M44_S3_6_X1_nr_NB0 (x_nor_M44_S3_6_x1 m44_pp33 VSS VSS) nmos w=1u l=100n
M44_S3_6_X1_iv_P0 (x_or_M44_S3_6_x1 x_nor_M44_S3_6_x1 VDD VDD) pmos w=2u l=100n
M44_S3_6_X1_iv_N0 (x_or_M44_S3_6_x1 x_nor_M44_S3_6_x1 VSS VSS) nmos w=1u l=100n
M44_S3_6_X1_nd_PA0 (x_nand_M44_S3_6_x1 m44_s2_6 VDD VDD) pmos w=2u l=100n
M44_S3_6_X1_nd_PB0 (x_nand_M44_S3_6_x1 m44_pp33 VDD VDD) pmos w=2u l=100n
M44_S3_6_X1_nd_NB0 (x_nand_M44_S3_6_x1 m44_pp33 nmid_M44_S3_6_X1_nd_0 VSS) nmos w=1u l=100n
M44_S3_6_X1_nd_NA0 (nmid_M44_S3_6_X1_nd_0 m44_s2_6 VSS VSS) nmos w=1u l=100n
M44_S3_6_X1_na_PA0 (x_pre_M44_S3_6_x1 x_or_M44_S3_6_x1 VDD VDD) pmos w=2u l=100n
M44_S3_6_X1_na_PB0 (x_pre_M44_S3_6_x1 x_nand_M44_S3_6_x1 VDD VDD) pmos w=2u l=100n
M44_S3_6_X1_na_NB0 (x_pre_M44_S3_6_x1 x_nand_M44_S3_6_x1 nmid_M44_S3_6_X1_na_0 VSS) nmos w=1u l=100n
M44_S3_6_X1_na_NA0 (nmid_M44_S3_6_X1_na_0 x_or_M44_S3_6_x1 VSS VSS) nmos w=1u l=100n
M44_S3_6_X1_xo_P0 (M44_S3_6_xab x_pre_M44_S3_6_x1 VDD VDD) pmos w=2u l=100n
M44_S3_6_X1_xo_N0 (M44_S3_6_xab x_pre_M44_S3_6_x1 VSS VSS) nmos w=1u l=100n
M44_S3_6_X2_nr_PA0 (pmid_M44_S3_6_X2_nr_0 M44_S3_6_xab VDD VDD) pmos w=2u l=100n
M44_S3_6_X2_nr_PB0 (x_nor_M44_S3_6_x2 m44_c3_6 pmid_M44_S3_6_X2_nr_0 VDD) pmos w=2u l=100n
M44_S3_6_X2_nr_NA0 (x_nor_M44_S3_6_x2 M44_S3_6_xab VSS VSS) nmos w=1u l=100n
M44_S3_6_X2_nr_NB0 (x_nor_M44_S3_6_x2 m44_c3_6 VSS VSS) nmos w=1u l=100n
M44_S3_6_X2_iv_P0 (x_or_M44_S3_6_x2 x_nor_M44_S3_6_x2 VDD VDD) pmos w=2u l=100n
M44_S3_6_X2_iv_N0 (x_or_M44_S3_6_x2 x_nor_M44_S3_6_x2 VSS VSS) nmos w=1u l=100n
M44_S3_6_X2_nd_PA0 (x_nand_M44_S3_6_x2 M44_S3_6_xab VDD VDD) pmos w=2u l=100n
M44_S3_6_X2_nd_PB0 (x_nand_M44_S3_6_x2 m44_c3_6 VDD VDD) pmos w=2u l=100n
M44_S3_6_X2_nd_NB0 (x_nand_M44_S3_6_x2 m44_c3_6 nmid_M44_S3_6_X2_nd_0 VSS) nmos w=1u l=100n
M44_S3_6_X2_nd_NA0 (nmid_M44_S3_6_X2_nd_0 M44_S3_6_xab VSS VSS) nmos w=1u l=100n
M44_S3_6_X2_na_PA0 (x_pre_M44_S3_6_x2 x_or_M44_S3_6_x2 VDD VDD) pmos w=2u l=100n
M44_S3_6_X2_na_PB0 (x_pre_M44_S3_6_x2 x_nand_M44_S3_6_x2 VDD VDD) pmos w=2u l=100n
M44_S3_6_X2_na_NB0 (x_pre_M44_S3_6_x2 x_nand_M44_S3_6_x2 nmid_M44_S3_6_X2_na_0 VSS) nmos w=1u l=100n
M44_S3_6_X2_na_NA0 (nmid_M44_S3_6_X2_na_0 x_or_M44_S3_6_x2 VSS VSS) nmos w=1u l=100n
M44_S3_6_X2_xo_P0 (P6 x_pre_M44_S3_6_x2 VDD VDD) pmos w=2u l=100n
M44_S3_6_X2_xo_N0 (P6 x_pre_M44_S3_6_x2 VSS VSS) nmos w=1u l=100n
M44_S3_6_AB_N_PA0 (M44_S3_6_ab_n m44_s2_6 VDD VDD) pmos w=2u l=100n
M44_S3_6_AB_N_PB0 (M44_S3_6_ab_n m44_pp33 VDD VDD) pmos w=2u l=100n
M44_S3_6_AB_N_NB0 (M44_S3_6_ab_n m44_pp33 nmid_M44_S3_6_AB_N_0 VSS) nmos w=1u l=100n
M44_S3_6_AB_N_NA0 (nmid_M44_S3_6_AB_N_0 m44_s2_6 VSS VSS) nmos w=1u l=100n
M44_S3_6_AB_I_P0 (M44_S3_6_ab M44_S3_6_ab_n VDD VDD) pmos w=2u l=100n
M44_S3_6_AB_I_N0 (M44_S3_6_ab M44_S3_6_ab_n VSS VSS) nmos w=1u l=100n
M44_S3_6_XC_N_PA0 (M44_S3_6_xc_n M44_S3_6_xab VDD VDD) pmos w=2u l=100n
M44_S3_6_XC_N_PB0 (M44_S3_6_xc_n m44_c3_6 VDD VDD) pmos w=2u l=100n
M44_S3_6_XC_N_NB0 (M44_S3_6_xc_n m44_c3_6 nmid_M44_S3_6_XC_N_0 VSS) nmos w=1u l=100n
M44_S3_6_XC_N_NA0 (nmid_M44_S3_6_XC_N_0 M44_S3_6_xab VSS VSS) nmos w=1u l=100n
M44_S3_6_XC_I_P0 (M44_S3_6_xc M44_S3_6_xc_n VDD VDD) pmos w=2u l=100n
M44_S3_6_XC_I_N0 (M44_S3_6_xc M44_S3_6_xc_n VSS VSS) nmos w=1u l=100n
M44_S3_6_OR_N_PA0 (pmid_M44_S3_6_OR_N_0 M44_S3_6_ab VDD VDD) pmos w=2u l=100n
M44_S3_6_OR_N_PB0 (m44_c3_7_n M44_S3_6_xc pmid_M44_S3_6_OR_N_0 VDD) pmos w=2u l=100n
M44_S3_6_OR_N_NA0 (m44_c3_7_n M44_S3_6_ab VSS VSS) nmos w=1u l=100n
M44_S3_6_OR_N_NB0 (m44_c3_7_n M44_S3_6_xc VSS VSS) nmos w=1u l=100n
M44_S3_6_OR_I_P0 (m44_c3_7 m44_c3_7_n VDD VDD) pmos w=2u l=100n
M44_S3_6_OR_I_N0 (m44_c3_7 m44_c3_7_n VSS VSS) nmos w=1u l=100n
M44_S3_7_X1_nr_PA0 (pmid_M44_S3_7_X1_nr_0 m44_s2_7 VDD VDD) pmos w=2u l=100n
M44_S3_7_X1_nr_PB0 (x_nor_M44_S3_7_x1 VSS pmid_M44_S3_7_X1_nr_0 VDD) pmos w=2u l=100n
M44_S3_7_X1_nr_NA0 (x_nor_M44_S3_7_x1 m44_s2_7 VSS VSS) nmos w=1u l=100n
M44_S3_7_X1_nr_NB0 (x_nor_M44_S3_7_x1 VSS VSS VSS) nmos w=1u l=100n
M44_S3_7_X1_iv_P0 (x_or_M44_S3_7_x1 x_nor_M44_S3_7_x1 VDD VDD) pmos w=2u l=100n
M44_S3_7_X1_iv_N0 (x_or_M44_S3_7_x1 x_nor_M44_S3_7_x1 VSS VSS) nmos w=1u l=100n
M44_S3_7_X1_nd_PA0 (x_nand_M44_S3_7_x1 m44_s2_7 VDD VDD) pmos w=2u l=100n
M44_S3_7_X1_nd_PB0 (x_nand_M44_S3_7_x1 VSS VDD VDD) pmos w=2u l=100n
M44_S3_7_X1_nd_NB0 (x_nand_M44_S3_7_x1 VSS nmid_M44_S3_7_X1_nd_0 VSS) nmos w=1u l=100n
M44_S3_7_X1_nd_NA0 (nmid_M44_S3_7_X1_nd_0 m44_s2_7 VSS VSS) nmos w=1u l=100n
M44_S3_7_X1_na_PA0 (x_pre_M44_S3_7_x1 x_or_M44_S3_7_x1 VDD VDD) pmos w=2u l=100n
M44_S3_7_X1_na_PB0 (x_pre_M44_S3_7_x1 x_nand_M44_S3_7_x1 VDD VDD) pmos w=2u l=100n
M44_S3_7_X1_na_NB0 (x_pre_M44_S3_7_x1 x_nand_M44_S3_7_x1 nmid_M44_S3_7_X1_na_0 VSS) nmos w=1u l=100n
M44_S3_7_X1_na_NA0 (nmid_M44_S3_7_X1_na_0 x_or_M44_S3_7_x1 VSS VSS) nmos w=1u l=100n
M44_S3_7_X1_xo_P0 (M44_S3_7_xab x_pre_M44_S3_7_x1 VDD VDD) pmos w=2u l=100n
M44_S3_7_X1_xo_N0 (M44_S3_7_xab x_pre_M44_S3_7_x1 VSS VSS) nmos w=1u l=100n
M44_S3_7_X2_nr_PA0 (pmid_M44_S3_7_X2_nr_0 M44_S3_7_xab VDD VDD) pmos w=2u l=100n
M44_S3_7_X2_nr_PB0 (x_nor_M44_S3_7_x2 m44_c3_7 pmid_M44_S3_7_X2_nr_0 VDD) pmos w=2u l=100n
M44_S3_7_X2_nr_NA0 (x_nor_M44_S3_7_x2 M44_S3_7_xab VSS VSS) nmos w=1u l=100n
M44_S3_7_X2_nr_NB0 (x_nor_M44_S3_7_x2 m44_c3_7 VSS VSS) nmos w=1u l=100n
M44_S3_7_X2_iv_P0 (x_or_M44_S3_7_x2 x_nor_M44_S3_7_x2 VDD VDD) pmos w=2u l=100n
M44_S3_7_X2_iv_N0 (x_or_M44_S3_7_x2 x_nor_M44_S3_7_x2 VSS VSS) nmos w=1u l=100n
M44_S3_7_X2_nd_PA0 (x_nand_M44_S3_7_x2 M44_S3_7_xab VDD VDD) pmos w=2u l=100n
M44_S3_7_X2_nd_PB0 (x_nand_M44_S3_7_x2 m44_c3_7 VDD VDD) pmos w=2u l=100n
M44_S3_7_X2_nd_NB0 (x_nand_M44_S3_7_x2 m44_c3_7 nmid_M44_S3_7_X2_nd_0 VSS) nmos w=1u l=100n
M44_S3_7_X2_nd_NA0 (nmid_M44_S3_7_X2_nd_0 M44_S3_7_xab VSS VSS) nmos w=1u l=100n
M44_S3_7_X2_na_PA0 (x_pre_M44_S3_7_x2 x_or_M44_S3_7_x2 VDD VDD) pmos w=2u l=100n
M44_S3_7_X2_na_PB0 (x_pre_M44_S3_7_x2 x_nand_M44_S3_7_x2 VDD VDD) pmos w=2u l=100n
M44_S3_7_X2_na_NB0 (x_pre_M44_S3_7_x2 x_nand_M44_S3_7_x2 nmid_M44_S3_7_X2_na_0 VSS) nmos w=1u l=100n
M44_S3_7_X2_na_NA0 (nmid_M44_S3_7_X2_na_0 x_or_M44_S3_7_x2 VSS VSS) nmos w=1u l=100n
M44_S3_7_X2_xo_P0 (P7 x_pre_M44_S3_7_x2 VDD VDD) pmos w=2u l=100n
M44_S3_7_X2_xo_N0 (P7 x_pre_M44_S3_7_x2 VSS VSS) nmos w=1u l=100n
M44_S3_7_AB_N_PA0 (M44_S3_7_ab_n m44_s2_7 VDD VDD) pmos w=2u l=100n
M44_S3_7_AB_N_PB0 (M44_S3_7_ab_n VSS VDD VDD) pmos w=2u l=100n
M44_S3_7_AB_N_NB0 (M44_S3_7_ab_n VSS nmid_M44_S3_7_AB_N_0 VSS) nmos w=1u l=100n
M44_S3_7_AB_N_NA0 (nmid_M44_S3_7_AB_N_0 m44_s2_7 VSS VSS) nmos w=1u l=100n
M44_S3_7_AB_I_P0 (M44_S3_7_ab M44_S3_7_ab_n VDD VDD) pmos w=2u l=100n
M44_S3_7_AB_I_N0 (M44_S3_7_ab M44_S3_7_ab_n VSS VSS) nmos w=1u l=100n
M44_S3_7_XC_N_PA0 (M44_S3_7_xc_n M44_S3_7_xab VDD VDD) pmos w=2u l=100n
M44_S3_7_XC_N_PB0 (M44_S3_7_xc_n m44_c3_7 VDD VDD) pmos w=2u l=100n
M44_S3_7_XC_N_NB0 (M44_S3_7_xc_n m44_c3_7 nmid_M44_S3_7_XC_N_0 VSS) nmos w=1u l=100n
M44_S3_7_XC_N_NA0 (nmid_M44_S3_7_XC_N_0 M44_S3_7_xab VSS VSS) nmos w=1u l=100n
M44_S3_7_XC_I_P0 (M44_S3_7_xc M44_S3_7_xc_n VDD VDD) pmos w=2u l=100n
M44_S3_7_XC_I_N0 (M44_S3_7_xc M44_S3_7_xc_n VSS VSS) nmos w=1u l=100n
M44_S3_7_OR_N_PA0 (pmid_M44_S3_7_OR_N_0 M44_S3_7_ab VDD VDD) pmos w=2u l=100n
M44_S3_7_OR_N_PB0 (m44_c3_8_n M44_S3_7_xc pmid_M44_S3_7_OR_N_0 VDD) pmos w=2u l=100n
M44_S3_7_OR_N_NA0 (m44_c3_8_n M44_S3_7_ab VSS VSS) nmos w=1u l=100n
M44_S3_7_OR_N_NB0 (m44_c3_8_n M44_S3_7_xc VSS VSS) nmos w=1u l=100n
M44_S3_7_OR_I_P0 (m44_c3_8 m44_c3_8_n VDD VDD) pmos w=2u l=100n
M44_S3_7_OR_I_N0 (m44_c3_8 m44_c3_8_n VSS VSS) nmos w=1u l=100n
ends mult4x4_x1
