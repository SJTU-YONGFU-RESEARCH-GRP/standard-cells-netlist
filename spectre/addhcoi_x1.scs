subckt addhcoi_x1 S CO A B VDD VSS
* Abstract subckt: behavioral/LVS placeholder — no MOS instances in the template.
ends addhcoi_x1
