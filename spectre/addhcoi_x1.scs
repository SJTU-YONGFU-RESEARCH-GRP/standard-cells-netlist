subckt addhcoi_x1 S CO A B VDD VSS
ADDH_S_nr_PA0 (pmid_ADDH_S_nr_0 A VDD VDD) pmos w=2u l=100n
ADDH_S_nr_PB0 (x_nor_0 B pmid_ADDH_S_nr_0 VDD) pmos w=2u l=100n
ADDH_S_nr_NA0 (x_nor_0 A VSS VSS) nmos w=1u l=100n
ADDH_S_nr_NB0 (x_nor_0 B VSS VSS) nmos w=1u l=100n
ADDH_S_iv_P0 (x_or_0 x_nor_0 VDD VDD) pmos w=2u l=100n
ADDH_S_iv_N0 (x_or_0 x_nor_0 VSS VSS) nmos w=1u l=100n
ADDH_S_nd_PA0 (x_nand_0 A VDD VDD) pmos w=2u l=100n
ADDH_S_nd_PB0 (x_nand_0 B VDD VDD) pmos w=2u l=100n
ADDH_S_nd_NB0 (x_nand_0 B nmid_ADDH_S_nd_0 VSS) nmos w=1u l=100n
ADDH_S_nd_NA0 (nmid_ADDH_S_nd_0 A VSS VSS) nmos w=1u l=100n
ADDH_S_na_PA0 (x_pre_0 x_or_0 VDD VDD) pmos w=2u l=100n
ADDH_S_na_PB0 (x_pre_0 x_nand_0 VDD VDD) pmos w=2u l=100n
ADDH_S_na_NB0 (x_pre_0 x_nand_0 nmid_ADDH_S_na_0 VSS) nmos w=1u l=100n
ADDH_S_na_NA0 (nmid_ADDH_S_na_0 x_or_0 VSS VSS) nmos w=1u l=100n
ADDH_S_xo_P0 (S x_pre_0 VDD VDD) pmos w=2u l=100n
ADDH_S_xo_N0 (S x_pre_0 VSS VSS) nmos w=1u l=100n
ADDH_COI_PA0 (CO A VDD VDD) pmos w=2u l=100n
ADDH_COI_PB0 (CO B VDD VDD) pmos w=2u l=100n
ADDH_COI_NB0 (CO B nmid_ADDH_COI_0 VSS) nmos w=1u l=100n
ADDH_COI_NA0 (nmid_ADDH_COI_0 A VSS VSS) nmos w=1u l=100n
ends addhcoi_x1
