subckt fsdnrbq_x1 Q CK D SI SE RD VDD VSS
FSDNRBQ_sei_P0 (FSDNRBQ_se_b SE VDD VDD) pmos w=2u l=100n
FSDNRBQ_sei_N0 (FSDNRBQ_se_b SE VSS VSS) nmos w=1u l=100n
FSDNRBQ_smx_MP0 (FSDNRBQ_din SE D VDD) pmos w=2u l=100n
FSDNRBQ_smx_MN0 (FSDNRBQ_din FSDNRBQ_se_b D VSS) nmos w=1u l=100n
FSDNRBQ_smx_MP1 (FSDNRBQ_din FSDNRBQ_se_b SI VDD) pmos w=2u l=100n
FSDNRBQ_smx_MN1 (FSDNRBQ_din SE SI VSS) nmos w=1u l=100n
FSDNRBQ_ck_P0 (FSDNRBQ_ck_b CK VDD VDD) pmos w=2u l=100n
FSDNRBQ_ck_N0 (FSDNRBQ_ck_b CK VSS VSS) nmos w=1u l=100n
FSDNRBQ_m_in_P (FSDNRBQ_m_n1 FSDNRBQ_ck_b FSDNRBQ_din VDD) pmos w=2u l=100n
FSDNRBQ_m_in_N (FSDNRBQ_m_n1 CK FSDNRBQ_din VSS) nmos w=1u l=100n
FSDNRBQ_m_i1_P0 (FSDNRBQ_m_n2 FSDNRBQ_m_n1 VDD VDD) pmos w=2u l=100n
FSDNRBQ_m_i1_N0 (FSDNRBQ_m_n2 FSDNRBQ_m_n1 VSS VSS) nmos w=1u l=100n
FSDNRBQ_m_i2_P0 (FSDNRBQ_m_n1 FSDNRBQ_m_n2 VDD VDD) pmos w=2u l=100n
FSDNRBQ_m_i2_N0 (FSDNRBQ_m_n1 FSDNRBQ_m_n2 VSS VSS) nmos w=1u l=100n
FSDNRBQ_m_fb_P (FSDNRBQ_m_n1 CK FSDNRBQ_m_n2 VDD) pmos w=2u l=100n
FSDNRBQ_m_fb_N (FSDNRBQ_m_n1 FSDNRBQ_ck_b FSDNRBQ_m_n2 VSS) nmos w=1u l=100n
FSDNRBQ_m_o_P0 (FSDNRBQ_qm FSDNRBQ_m_n2 VDD VDD) pmos w=2u l=100n
FSDNRBQ_m_o_N0 (FSDNRBQ_qm FSDNRBQ_m_n2 VSS VSS) nmos w=1u l=100n
FSDNRBQ_s_in_P (FSDNRBQ_s_n1 CK FSDNRBQ_qm VDD) pmos w=2u l=100n
FSDNRBQ_s_in_N (FSDNRBQ_s_n1 FSDNRBQ_ck_b FSDNRBQ_qm VSS) nmos w=1u l=100n
FSDNRBQ_s_i1_P0 (FSDNRBQ_s_n2 FSDNRBQ_s_n1 VDD VDD) pmos w=2u l=100n
FSDNRBQ_s_i1_N0 (FSDNRBQ_s_n2 FSDNRBQ_s_n1 VSS VSS) nmos w=1u l=100n
FSDNRBQ_s_i2_P0 (FSDNRBQ_s_n1 FSDNRBQ_s_n2 VDD VDD) pmos w=2u l=100n
FSDNRBQ_s_i2_N0 (FSDNRBQ_s_n1 FSDNRBQ_s_n2 VSS VSS) nmos w=1u l=100n
FSDNRBQ_s_fb_P (FSDNRBQ_s_n1 FSDNRBQ_ck_b FSDNRBQ_s_n2 VDD) pmos w=2u l=100n
FSDNRBQ_s_fb_N (FSDNRBQ_s_n1 CK FSDNRBQ_s_n2 VSS) nmos w=1u l=100n
FSDNRBQ_s_o_P0 (Q FSDNRBQ_s_n2 VDD VDD) pmos w=2u l=100n
FSDNRBQ_s_o_N0 (Q FSDNRBQ_s_n2 VSS VSS) nmos w=1u l=100n
FSDNRBQ_rdi_P0 (FSDNRBQ_rd_b RD VDD VDD) pmos w=2u l=100n
FSDNRBQ_rdi_N0 (FSDNRBQ_rd_b RD VSS VSS) nmos w=1u l=100n
FSDNRBQ_rcl (Q FSDNRBQ_rd_b VSS VSS) nmos w=1u l=100n
ends fsdnrbq_x1
