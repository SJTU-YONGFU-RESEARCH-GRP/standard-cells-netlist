subckt fsdnrbq_x1 Q CK D SI SE RD VDD VSS
* Abstract subckt: behavioral/LVS placeholder — no MOS instances in the template.
* ref_lib analogue: LIB_FSDNRBQ_* in ref_lib/lib_hd_ref.v; LIBHD_* in ref_lib/lib_hd_ref.spx (rails often VDD VSS VBP VBN)
ends fsdnrbq_x1
