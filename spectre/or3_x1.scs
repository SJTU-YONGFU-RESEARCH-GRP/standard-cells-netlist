subckt or3_x1 A1 A2 A3 X VDD VSS
O30_PA0 (pmid1 A1 VDD VDD) pmos w=2u l=100n
O30_PB0 (pmid2 A2 pmid1 VDD) pmos w=2u l=100n
O30_PC0 (nor3_out A3 pmid2 VDD) pmos w=2u l=100n
O30_NA0 (nor3_out A1 VSS VSS) nmos w=1u l=100n
O30_NB0 (nor3_out A2 VSS VSS) nmos w=1u l=100n
O30_NC0 (nor3_out A3 VSS VSS) nmos w=1u l=100n
O3I0_P0 (X nor3_out VDD VDD) pmos w=2u l=100n
O3I0_N0 (X nor3_out VSS VSS) nmos w=1u l=100n
ends or3_x1
