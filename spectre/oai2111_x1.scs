subckt oai2111_x1 A1 A2 B1 B2 B3 X VDD VSS
OAI2111OR0_PA0 (pmid_OAI2111OR0_0 A1 VDD VDD) pmos w=2u l=100n
OAI2111OR0_PB0 (oai2111_or_n A2 pmid_OAI2111OR0_0 VDD) pmos w=2u l=100n
OAI2111OR0_NA0 (oai2111_or_n A1 VSS VSS) nmos w=1u l=100n
OAI2111OR0_NB0 (oai2111_or_n A2 VSS VSS) nmos w=1u l=100n
OAI2111ORI0_P0 (oai2111_or oai2111_or_n VDD VDD) pmos w=2u l=100n
OAI2111ORI0_N0 (oai2111_or oai2111_or_n VSS VSS) nmos w=1u l=100n
OAI2111N40_PA0 (X oai2111_or VDD VDD) pmos w=2u l=100n
OAI2111N40_PB0 (X B1 VDD VDD) pmos w=2u l=100n
OAI2111N40_PC0 (X B2 VDD VDD) pmos w=2u l=100n
OAI2111N40_PD0 (X B3 VDD VDD) pmos w=2u l=100n
OAI2111N40_ND0 (X B3 na4_3 VSS) nmos w=1u l=100n
OAI2111N40_NC0 (na4_3 B2 na4_2 VSS) nmos w=1u l=100n
OAI2111N40_NB0 (na4_2 B1 na4_1 VSS) nmos w=1u l=100n
OAI2111N40_NA0 (na4_1 oai2111_or VSS VSS) nmos w=1u l=100n
ends oai2111_x1
