subckt or4_x1 A1 A2 A3 A4 X VDD VSS
O40_PA0 (no4_1 A1 VDD VDD) pmos w=2u l=100n
O40_PB0 (no4_2 A2 no4_1 VDD) pmos w=2u l=100n
O40_PC0 (no4_3 A3 no4_2 VDD) pmos w=2u l=100n
O40_PD0 (nor4_out A4 no4_3 VDD) pmos w=2u l=100n
O40_NA0 (nor4_out A1 VSS VSS) nmos w=1u l=100n
O40_NB0 (nor4_out A2 VSS VSS) nmos w=1u l=100n
O40_NC0 (nor4_out A3 VSS VSS) nmos w=1u l=100n
O40_ND0 (nor4_out A4 VSS VSS) nmos w=1u l=100n
O4I0_P0 (X nor4_out VDD VDD) pmos w=2u l=100n
O4I0_N0 (X nor4_out VSS VSS) nmos w=1u l=100n
ends or4_x1
