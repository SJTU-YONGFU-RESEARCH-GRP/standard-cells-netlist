subckt nand2i_x1 A1 A2 X VDD VSS
MPA0 (X A1 VDD VDD) pmos w=2u l=100n
MPB0 (X A2 VDD VDD) pmos w=2u l=100n
MNB0 (X A2 nmid_M0 VSS) nmos w=1u l=100n
MNA0 (nmid_M0 A1 VSS VSS) nmos w=1u l=100n
ends nand2i_x1
