subckt nand2i_x1 A B X VDD VSS
MPA0 (X A VDD VDD) pmos w=2u l=100n
MPB0 (X B VDD VDD) pmos w=2u l=100n
MNB0 (X B nmid_M0 VSS) nmos w=1u l=100n
MNA0 (nmid_M0 A VSS VSS) nmos w=1u l=100n
ends nand2i_x1
