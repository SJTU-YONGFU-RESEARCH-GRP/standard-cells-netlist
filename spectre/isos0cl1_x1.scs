subckt isos0cl1_x1 VDD VSS VDDR VBP VBN X A EN0
* Power-management helper: ref_lib-style rails listed first.
R2P1 (p_nor2_mid A VDDR VBP) pmos w=2u l=100n
R2P2 (n_or EN0 p_nor2_mid VBP) pmos w=2u l=100n
R2N1 (n_or A VSS VBN) nmos w=1u l=100n
R2N2 (n_or EN0 VSS VBN) nmos w=1u l=100n
I4P (X n_or VDDR VBP) pmos w=2u l=100n
I4N (X n_or VSS VBN) nmos w=1u l=100n
ends isos0cl1_x1
