subckt ao32_x1 A1 A2 A3 B1 B2 X VDD VSS
AO32A0_PA0 (ao32_a_n A1 VDD VDD) pmos w=2u l=100n
AO32A0_PB0 (ao32_a_n A2 VDD VDD) pmos w=2u l=100n
AO32A0_PC0 (ao32_a_n A3 VDD VDD) pmos w=2u l=100n
AO32A0_NC0 (ao32_a_n A3 nmid2 VSS) nmos w=1u l=100n
AO32A0_NB0 (nmid2 A2 nmid1 VSS) nmos w=1u l=100n
AO32A0_NA0 (nmid1 A1 VSS VSS) nmos w=1u l=100n
AO32AI0_P0 (ao32_a ao32_a_n VDD VDD) pmos w=2u l=100n
AO32AI0_N0 (ao32_a ao32_a_n VSS VSS) nmos w=1u l=100n
AO32B0_PA0 (ao32_b_n B1 VDD VDD) pmos w=2u l=100n
AO32B0_PB0 (ao32_b_n B2 VDD VDD) pmos w=2u l=100n
AO32B0_NB0 (ao32_b_n B2 nmid_AO32B0_0 VSS) nmos w=1u l=100n
AO32B0_NA0 (nmid_AO32B0_0 B1 VSS VSS) nmos w=1u l=100n
AO32BI0_P0 (ao32_b ao32_b_n VDD VDD) pmos w=2u l=100n
AO32BI0_N0 (ao32_b ao32_b_n VSS VSS) nmos w=1u l=100n
AO32N20_PA0 (pmid_AO32N20_0 ao32_a VDD VDD) pmos w=2u l=100n
AO32N20_PB0 (ao32_or_n ao32_b pmid_AO32N20_0 VDD) pmos w=2u l=100n
AO32N20_NA0 (ao32_or_n ao32_a VSS VSS) nmos w=1u l=100n
AO32N20_NB0 (ao32_or_n ao32_b VSS VSS) nmos w=1u l=100n
AO32O0_P0 (X ao32_or_n VDD VDD) pmos w=2u l=100n
AO32O0_N0 (X ao32_or_n VSS VSS) nmos w=1u l=100n
ends ao32_x1
