subckt mux4_x1 D0 D1 D2 D3 S0 S1 X VDD VSS
M4S0_P0 (s0_b S0 VDD VDD) pmos w=2u l=100n
M4S0_N0 (s0_b S0 VSS VSS) nmos w=1u l=100n
M4S1_P0 (s1_b S1 VDD VDD) pmos w=2u l=100n
M4S1_N0 (s1_b S1 VSS VSS) nmos w=1u l=100n
M4a0_MP0 (mux_m01 S0 D0 VDD) pmos w=2u l=100n
M4a0_MN0 (mux_m01 s0_b D0 VSS) nmos w=1u l=100n
M4a0_MP1 (mux_m01 s0_b D1 VDD) pmos w=2u l=100n
M4a0_MN1 (mux_m01 S0 D1 VSS) nmos w=1u l=100n
M4b0_MP0 (mux_m23 S0 D2 VDD) pmos w=2u l=100n
M4b0_MN0 (mux_m23 s0_b D2 VSS) nmos w=1u l=100n
M4b0_MP1 (mux_m23 s0_b D3 VDD) pmos w=2u l=100n
M4b0_MN1 (mux_m23 S0 D3 VSS) nmos w=1u l=100n
M4c0_MP0 (X S1 mux_m01 VDD) pmos w=2u l=100n
M4c0_MN0 (X s1_b mux_m01 VSS) nmos w=1u l=100n
M4c0_MP1 (X s1_b mux_m23 VDD) pmos w=2u l=100n
M4c0_MN1 (X S1 mux_m23 VSS) nmos w=1u l=100n
ends mux4_x1
