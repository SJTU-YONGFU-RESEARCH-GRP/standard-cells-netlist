subckt nand4_x1 A1 A2 A3 A4 X VDD VSS
MPA0 (X A1 VDD VDD) pmos w=2u l=100n
MPB0 (X A2 VDD VDD) pmos w=2u l=100n
MPC0 (X A3 VDD VDD) pmos w=2u l=100n
MPD0 (X A4 VDD VDD) pmos w=2u l=100n
MND0 (X A4 na4_3 VSS) nmos w=1u l=100n
MNC0 (na4_3 A3 na4_2 VSS) nmos w=1u l=100n
MNB0 (na4_2 A2 na4_1 VSS) nmos w=1u l=100n
MNA0 (na4_1 A1 VSS VSS) nmos w=1u l=100n
ends nand4_x1
