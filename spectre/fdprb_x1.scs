subckt fdprb_x1 Q QN CK D RD VDD VSS
FDPRB_ck_P0 (FDPRB_ck_b CK VDD VDD) pmos w=2u l=100n
FDPRB_ck_N0 (FDPRB_ck_b CK VSS VSS) nmos w=1u l=100n
FDPRB_m_in_P (FDPRB_m_n1 CK D VDD) pmos w=2u l=100n
FDPRB_m_in_N (FDPRB_m_n1 FDPRB_ck_b D VSS) nmos w=1u l=100n
FDPRB_m_i1_P0 (FDPRB_m_n2 FDPRB_m_n1 VDD VDD) pmos w=2u l=100n
FDPRB_m_i1_N0 (FDPRB_m_n2 FDPRB_m_n1 VSS VSS) nmos w=1u l=100n
FDPRB_m_i2_P0 (FDPRB_m_n1 FDPRB_m_n2 VDD VDD) pmos w=2u l=100n
FDPRB_m_i2_N0 (FDPRB_m_n1 FDPRB_m_n2 VSS VSS) nmos w=1u l=100n
FDPRB_m_fb_P (FDPRB_m_n1 FDPRB_ck_b FDPRB_m_n2 VDD) pmos w=2u l=100n
FDPRB_m_fb_N (FDPRB_m_n1 CK FDPRB_m_n2 VSS) nmos w=1u l=100n
FDPRB_m_o_P0 (FDPRB_qm FDPRB_m_n2 VDD VDD) pmos w=2u l=100n
FDPRB_m_o_N0 (FDPRB_qm FDPRB_m_n2 VSS VSS) nmos w=1u l=100n
FDPRB_s_in_P (FDPRB_s_n1 FDPRB_ck_b FDPRB_qm VDD) pmos w=2u l=100n
FDPRB_s_in_N (FDPRB_s_n1 CK FDPRB_qm VSS) nmos w=1u l=100n
FDPRB_s_i1_P0 (FDPRB_s_n2 FDPRB_s_n1 VDD VDD) pmos w=2u l=100n
FDPRB_s_i1_N0 (FDPRB_s_n2 FDPRB_s_n1 VSS VSS) nmos w=1u l=100n
FDPRB_s_i2_P0 (FDPRB_s_n1 FDPRB_s_n2 VDD VDD) pmos w=2u l=100n
FDPRB_s_i2_N0 (FDPRB_s_n1 FDPRB_s_n2 VSS VSS) nmos w=1u l=100n
FDPRB_s_fb_P (FDPRB_s_n1 CK FDPRB_s_n2 VDD) pmos w=2u l=100n
FDPRB_s_fb_N (FDPRB_s_n1 FDPRB_ck_b FDPRB_s_n2 VSS) nmos w=1u l=100n
FDPRB_s_o_P0 (Q FDPRB_s_n2 VDD VDD) pmos w=2u l=100n
FDPRB_s_o_N0 (Q FDPRB_s_n2 VSS VSS) nmos w=1u l=100n
FDPRB_qn_P0 (QN Q VDD VDD) pmos w=2u l=100n
FDPRB_qn_N0 (QN Q VSS VSS) nmos w=1u l=100n
FDPRB_rdi_P0 (FDPRB_rd_b RD VDD VDD) pmos w=2u l=100n
FDPRB_rdi_N0 (FDPRB_rd_b RD VSS VSS) nmos w=1u l=100n
FDPRB_rcl (Q FDPRB_rd_b VSS VSS) nmos w=1u l=100n
ends fdprb_x1
