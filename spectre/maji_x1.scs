subckt maji_x1 X A1 A2 A3 VDD VSS
MAJab0_PA0 (maj_ab_n A1 VDD VDD) pmos w=2u l=100n
MAJab0_PB0 (maj_ab_n A2 VDD VDD) pmos w=2u l=100n
MAJab0_NB0 (maj_ab_n A2 nmid_MAJab0_0 VSS) nmos w=1u l=100n
MAJab0_NA0 (nmid_MAJab0_0 A1 VSS VSS) nmos w=1u l=100n
MAJac0_PA0 (maj_ac_n A1 VDD VDD) pmos w=2u l=100n
MAJac0_PB0 (maj_ac_n A3 VDD VDD) pmos w=2u l=100n
MAJac0_NB0 (maj_ac_n A3 nmid_MAJac0_0 VSS) nmos w=1u l=100n
MAJac0_NA0 (nmid_MAJac0_0 A1 VSS VSS) nmos w=1u l=100n
MAJbc0_PA0 (maj_bc_n A2 VDD VDD) pmos w=2u l=100n
MAJbc0_PB0 (maj_bc_n A3 VDD VDD) pmos w=2u l=100n
MAJbc0_NB0 (maj_bc_n A3 nmid_MAJbc0_0 VSS) nmos w=1u l=100n
MAJbc0_NA0 (nmid_MAJbc0_0 A2 VSS VSS) nmos w=1u l=100n
MAJabi0_P0 (maj_ab maj_ab_n VDD VDD) pmos w=2u l=100n
MAJabi0_N0 (maj_ab maj_ab_n VSS VSS) nmos w=1u l=100n
MAJaci0_P0 (maj_ac maj_ac_n VDD VDD) pmos w=2u l=100n
MAJaci0_N0 (maj_ac maj_ac_n VSS VSS) nmos w=1u l=100n
MAJbci0_P0 (maj_bc maj_bc_n VDD VDD) pmos w=2u l=100n
MAJbci0_N0 (maj_bc maj_bc_n VSS VSS) nmos w=1u l=100n
MAJor10_PA0 (pmid_MAJor10_0 maj_ab VDD VDD) pmos w=2u l=100n
MAJor10_PB0 (maj_or_n maj_ac pmid_MAJor10_0 VDD) pmos w=2u l=100n
MAJor10_NA0 (maj_or_n maj_ab VSS VSS) nmos w=1u l=100n
MAJor10_NB0 (maj_or_n maj_ac VSS VSS) nmos w=1u l=100n
MAJor1i0_P0 (maj_or maj_or_n VDD VDD) pmos w=2u l=100n
MAJor1i0_N0 (maj_or maj_or_n VSS VSS) nmos w=1u l=100n
MAJor20_PA0 (pmid_MAJor20_0 maj_or VDD VDD) pmos w=2u l=100n
MAJor20_PB0 (maj_y_n maj_bc pmid_MAJor20_0 VDD) pmos w=2u l=100n
MAJor20_NA0 (maj_y_n maj_or VSS VSS) nmos w=1u l=100n
MAJor20_NB0 (maj_y_n maj_bc VSS VSS) nmos w=1u l=100n
MAJOa0_P0 (maj_y_nb maj_y_n VDD VDD) pmos w=2u l=100n
MAJOa0_N0 (maj_y_nb maj_y_n VSS VSS) nmos w=1u l=100n
MAJOb0_P0 (X maj_y_nb VDD VDD) pmos w=2u l=100n
MAJOb0_N0 (X maj_y_nb VSS VSS) nmos w=1u l=100n
ends maji_x1
