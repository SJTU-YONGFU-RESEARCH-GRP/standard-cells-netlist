subckt pgatdrv_x1 VDDP VSS VBP VBN VDDC ENXB
* Power-management helper: ref_lib-style rails listed first (VDD,VSS,VDDR,VBP,VBN).
* Abstract subckt (no MOS instances).
* No transistor template was found for this kind/drive.
ends pgatdrv_x1
